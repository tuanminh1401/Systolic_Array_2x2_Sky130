* NGSPICE file created from systolic_array_2x2.ext - technology: sky130A

* Black-box entry subcircuit for sky130_fd_sc_hd__fill_1 abstract view
.subckt sky130_fd_sc_hd__fill_1 VGND VNB VPB VPWR
.ends

* Black-box entry subcircuit for sky130_fd_sc_hd__decap_8 abstract view
.subckt sky130_fd_sc_hd__decap_8 VGND VNB VPB VPWR
.ends

* Black-box entry subcircuit for sky130_ef_sc_hd__decap_12 abstract view
.subckt sky130_ef_sc_hd__decap_12 VPWR VGND VPB VNB
.ends

* Black-box entry subcircuit for sky130_fd_sc_hd__decap_3 abstract view
.subckt sky130_fd_sc_hd__decap_3 VGND VNB VPB VPWR
.ends

* Black-box entry subcircuit for sky130_fd_sc_hd__decap_6 abstract view
.subckt sky130_fd_sc_hd__decap_6 VGND VNB VPB VPWR
.ends

* Black-box entry subcircuit for sky130_fd_sc_hd__tapvpwrvgnd_1 abstract view
.subckt sky130_fd_sc_hd__tapvpwrvgnd_1 VGND VPWR
.ends

* Black-box entry subcircuit for sky130_fd_sc_hd__diode_2 abstract view
.subckt sky130_fd_sc_hd__diode_2 DIODE VGND VNB VPB VPWR
.ends

* Black-box entry subcircuit for sky130_fd_sc_hd__decap_4 abstract view
.subckt sky130_fd_sc_hd__decap_4 VGND VNB VPB VPWR
.ends

* Black-box entry subcircuit for sky130_fd_sc_hd__fill_2 abstract view
.subckt sky130_fd_sc_hd__fill_2 VGND VNB VPB VPWR
.ends

* Black-box entry subcircuit for sky130_fd_sc_hd__clkbuf_4 abstract view
.subckt sky130_fd_sc_hd__clkbuf_4 A VGND VNB VPB VPWR X
.ends

* Black-box entry subcircuit for sky130_fd_sc_hd__clkbuf_8 abstract view
.subckt sky130_fd_sc_hd__clkbuf_8 A VGND VNB VPB VPWR X
.ends

* Black-box entry subcircuit for sky130_fd_sc_hd__buf_4 abstract view
.subckt sky130_fd_sc_hd__buf_4 A VGND VNB VPB VPWR X
.ends

* Black-box entry subcircuit for sky130_fd_sc_hd__buf_1 abstract view
.subckt sky130_fd_sc_hd__buf_1 A VGND VNB VPB VPWR X
.ends

* Black-box entry subcircuit for sky130_fd_sc_hd__clkbuf_2 abstract view
.subckt sky130_fd_sc_hd__clkbuf_2 A VGND VNB VPB VPWR X
.ends

* Black-box entry subcircuit for sky130_fd_sc_hd__clkbuf_16 abstract view
.subckt sky130_fd_sc_hd__clkbuf_16 A VGND VNB VPB VPWR X
.ends

* Black-box entry subcircuit for sky130_fd_sc_hd__dlymetal6s2s_1 abstract view
.subckt sky130_fd_sc_hd__dlymetal6s2s_1 A VGND VNB VPB VPWR X
.ends

* Black-box entry subcircuit for processing_element abstract view
.subckt processing_element VGND VPWR act_in[0] act_in[10] act_in[11] act_in[12] act_in[13]
+ act_in[14] act_in[15] act_in[1] act_in[2] act_in[3] act_in[4] act_in[5] act_in[6]
+ act_in[7] act_in[8] act_in[9] act_out[0] act_out[10] act_out[11] act_out[12] act_out[13]
+ act_out[14] act_out[15] act_out[1] act_out[2] act_out[3] act_out[4] act_out[5] act_out[6]
+ act_out[7] act_out[8] act_out[9] clk load_weight psum_in[0] psum_in[10] psum_in[11]
+ psum_in[12] psum_in[13] psum_in[14] psum_in[15] psum_in[16] psum_in[17] psum_in[18]
+ psum_in[19] psum_in[1] psum_in[20] psum_in[21] psum_in[22] psum_in[23] psum_in[24]
+ psum_in[25] psum_in[26] psum_in[27] psum_in[28] psum_in[29] psum_in[2] psum_in[30]
+ psum_in[31] psum_in[3] psum_in[4] psum_in[5] psum_in[6] psum_in[7] psum_in[8] psum_in[9]
+ psum_out[0] psum_out[10] psum_out[11] psum_out[12] psum_out[13] psum_out[14] psum_out[15]
+ psum_out[16] psum_out[17] psum_out[18] psum_out[19] psum_out[1] psum_out[20] psum_out[21]
+ psum_out[22] psum_out[23] psum_out[24] psum_out[25] psum_out[26] psum_out[27] psum_out[28]
+ psum_out[29] psum_out[2] psum_out[30] psum_out[31] psum_out[3] psum_out[4] psum_out[5]
+ psum_out[6] psum_out[7] psum_out[8] psum_out[9] rst_n valid_in valid_out weight_in[0]
+ weight_in[10] weight_in[11] weight_in[12] weight_in[13] weight_in[14] weight_in[15]
+ weight_in[1] weight_in[2] weight_in[3] weight_in[4] weight_in[5] weight_in[6] weight_in[7]
+ weight_in[8] weight_in[9]
.ends

.subckt systolic_array_2x2 VGND VPWR act_row0_in[0] act_row0_in[10] act_row0_in[11]
+ act_row0_in[12] act_row0_in[13] act_row0_in[14] act_row0_in[15] act_row0_in[1] act_row0_in[2]
+ act_row0_in[3] act_row0_in[4] act_row0_in[5] act_row0_in[6] act_row0_in[7] act_row0_in[8]
+ act_row0_in[9] act_row1_in[0] act_row1_in[10] act_row1_in[11] act_row1_in[12] act_row1_in[13]
+ act_row1_in[14] act_row1_in[15] act_row1_in[1] act_row1_in[2] act_row1_in[3] act_row1_in[4]
+ act_row1_in[5] act_row1_in[6] act_row1_in[7] act_row1_in[8] act_row1_in[9] clk load_weight
+ psum_col0_in[0] psum_col0_in[10] psum_col0_in[11] psum_col0_in[12] psum_col0_in[13]
+ psum_col0_in[14] psum_col0_in[15] psum_col0_in[16] psum_col0_in[17] psum_col0_in[18]
+ psum_col0_in[19] psum_col0_in[1] psum_col0_in[20] psum_col0_in[21] psum_col0_in[22]
+ psum_col0_in[23] psum_col0_in[24] psum_col0_in[25] psum_col0_in[26] psum_col0_in[27]
+ psum_col0_in[28] psum_col0_in[29] psum_col0_in[2] psum_col0_in[30] psum_col0_in[31]
+ psum_col0_in[3] psum_col0_in[4] psum_col0_in[5] psum_col0_in[6] psum_col0_in[7]
+ psum_col0_in[8] psum_col0_in[9] psum_col0_out[0] psum_col0_out[10] psum_col0_out[11]
+ psum_col0_out[12] psum_col0_out[13] psum_col0_out[14] psum_col0_out[15] psum_col0_out[16]
+ psum_col0_out[17] psum_col0_out[18] psum_col0_out[19] psum_col0_out[1] psum_col0_out[20]
+ psum_col0_out[21] psum_col0_out[22] psum_col0_out[23] psum_col0_out[24] psum_col0_out[25]
+ psum_col0_out[26] psum_col0_out[27] psum_col0_out[28] psum_col0_out[29] psum_col0_out[2]
+ psum_col0_out[30] psum_col0_out[31] psum_col0_out[3] psum_col0_out[4] psum_col0_out[5]
+ psum_col0_out[6] psum_col0_out[7] psum_col0_out[8] psum_col0_out[9] psum_col1_in[0]
+ psum_col1_in[10] psum_col1_in[11] psum_col1_in[12] psum_col1_in[13] psum_col1_in[14]
+ psum_col1_in[15] psum_col1_in[16] psum_col1_in[17] psum_col1_in[18] psum_col1_in[19]
+ psum_col1_in[1] psum_col1_in[20] psum_col1_in[21] psum_col1_in[22] psum_col1_in[23]
+ psum_col1_in[24] psum_col1_in[25] psum_col1_in[26] psum_col1_in[27] psum_col1_in[28]
+ psum_col1_in[29] psum_col1_in[2] psum_col1_in[30] psum_col1_in[31] psum_col1_in[3]
+ psum_col1_in[4] psum_col1_in[5] psum_col1_in[6] psum_col1_in[7] psum_col1_in[8]
+ psum_col1_in[9] psum_col1_out[0] psum_col1_out[10] psum_col1_out[11] psum_col1_out[12]
+ psum_col1_out[13] psum_col1_out[14] psum_col1_out[15] psum_col1_out[16] psum_col1_out[17]
+ psum_col1_out[18] psum_col1_out[19] psum_col1_out[1] psum_col1_out[20] psum_col1_out[21]
+ psum_col1_out[22] psum_col1_out[23] psum_col1_out[24] psum_col1_out[25] psum_col1_out[26]
+ psum_col1_out[27] psum_col1_out[28] psum_col1_out[29] psum_col1_out[2] psum_col1_out[30]
+ psum_col1_out[31] psum_col1_out[3] psum_col1_out[4] psum_col1_out[5] psum_col1_out[6]
+ psum_col1_out[7] psum_col1_out[8] psum_col1_out[9] rst_n valid_row0_in valid_row0_out
+ valid_row1_in valid_row1_out w00[0] w00[10] w00[11] w00[12] w00[13] w00[14] w00[15]
+ w00[1] w00[2] w00[3] w00[4] w00[5] w00[6] w00[7] w00[8] w00[9] w01[0] w01[10] w01[11]
+ w01[12] w01[13] w01[14] w01[15] w01[1] w01[2] w01[3] w01[4] w01[5] w01[6] w01[7]
+ w01[8] w01[9] w10[0] w10[10] w10[11] w10[12] w10[13] w10[14] w10[15] w10[1] w10[2]
+ w10[3] w10[4] w10[5] w10[6] w10[7] w10[8] w10[9] w11[0] w11[10] w11[11] w11[12]
+ w11[13] w11[14] w11[15] w11[1] w11[2] w11[3] w11[4] w11[5] w11[6] w11[7] w11[8]
+ w11[9]
XFILLER_0_59_1253 VGND VGND VPWR VPWR sky130_fd_sc_hd__fill_1
XFILLER_0_179_647 VGND VGND VPWR VPWR sky130_fd_sc_hd__decap_8
XFILLER_0_171_1323 VPWR VGND VPWR VGND sky130_ef_sc_hd__decap_12
XFILLER_0_210_905 VGND VGND VPWR VPWR sky130_fd_sc_hd__decap_3
XFILLER_0_132_1307 VPWR VGND VPWR VGND sky130_ef_sc_hd__decap_12
XFILLER_0_194_617 VGND VGND VPWR VPWR sky130_fd_sc_hd__fill_1
XFILLER_0_77_645 VGND VGND VPWR VPWR sky130_fd_sc_hd__fill_1
XFILLER_0_66_1213 VPWR VGND VPWR VGND sky130_ef_sc_hd__decap_12
XFILLER_0_103_647 VPWR VGND VPWR VGND sky130_ef_sc_hd__decap_12
XFILLER_0_7_81 VGND VGND VPWR VPWR sky130_fd_sc_hd__decap_3
XFILLER_0_176_1201 VPWR VGND VPWR VGND sky130_ef_sc_hd__decap_12
XFILLER_0_217_559 VGND VGND VPWR VPWR sky130_fd_sc_hd__fill_1
XFILLER_0_213_721 VGND VGND VPWR VPWR sky130_fd_sc_hd__decap_6
XFILLER_0_217_1231 VGND VGND VPWR VPWR sky130_fd_sc_hd__fill_1
XTAP_2501 VGND VPWR sky130_fd_sc_hd__tapvpwrvgnd_1
XFILLER_0_38_1337 VGND VGND VPWR VPWR sky130_fd_sc_hd__fill_1
XANTENNA_input127_A w01[4] VGND VGND VPWR VPWR sky130_fd_sc_hd__diode_2
XTAP_2512 VGND VPWR sky130_fd_sc_hd__tapvpwrvgnd_1
XFILLER_0_213_765 VPWR VGND VPWR VGND sky130_ef_sc_hd__decap_12
XTAP_2545 VGND VPWR sky130_fd_sc_hd__tapvpwrvgnd_1
XTAP_2534 VGND VPWR sky130_fd_sc_hd__tapvpwrvgnd_1
XFILLER_0_212_253 VPWR VGND VPWR VGND sky130_ef_sc_hd__decap_12
XTAP_2523 VGND VPWR sky130_fd_sc_hd__tapvpwrvgnd_1
XTAP_1800 VGND VPWR sky130_fd_sc_hd__tapvpwrvgnd_1
XTAP_2567 VGND VPWR sky130_fd_sc_hd__tapvpwrvgnd_1
XTAP_2556 VGND VPWR sky130_fd_sc_hd__tapvpwrvgnd_1
XTAP_2578 VGND VPWR sky130_fd_sc_hd__tapvpwrvgnd_1
XFILLER_0_185_617 VPWR VGND VPWR VGND sky130_ef_sc_hd__decap_12
XTAP_1833 VGND VPWR sky130_fd_sc_hd__tapvpwrvgnd_1
XTAP_1811 VGND VPWR sky130_fd_sc_hd__tapvpwrvgnd_1
XTAP_1822 VGND VPWR sky130_fd_sc_hd__tapvpwrvgnd_1
XTAP_2589 VGND VPWR sky130_fd_sc_hd__tapvpwrvgnd_1
XTAP_1866 VGND VPWR sky130_fd_sc_hd__tapvpwrvgnd_1
XTAP_1855 VGND VPWR sky130_fd_sc_hd__tapvpwrvgnd_1
XFILLER_0_3_1313 VPWR VGND VPWR VGND sky130_ef_sc_hd__decap_12
XTAP_1844 VGND VPWR sky130_fd_sc_hd__tapvpwrvgnd_1
XTAP_1877 VGND VPWR sky130_fd_sc_hd__tapvpwrvgnd_1
XTAP_1899 VGND VPWR sky130_fd_sc_hd__tapvpwrvgnd_1
XTAP_1888 VGND VPWR sky130_fd_sc_hd__tapvpwrvgnd_1
XANTENNA_input92_A psum_col1_in[4] VGND VGND VPWR VPWR sky130_fd_sc_hd__diode_2
XFILLER_0_10_1201 VPWR VGND VPWR VGND sky130_ef_sc_hd__decap_12
XFILLER_0_107_953 VPWR VGND VPWR VGND sky130_ef_sc_hd__decap_12
XFILLER_0_3_609 VGND VGND VPWR VPWR sky130_fd_sc_hd__decap_6
XFILLER_0_183_1249 VGND VGND VPWR VPWR sky130_fd_sc_hd__decap_4
XFILLER_0_210_41 VPWR VGND VPWR VGND sky130_ef_sc_hd__decap_12
XFILLER_0_210_85 VGND VGND VPWR VPWR sky130_fd_sc_hd__decap_4
XFILLER_0_107_1033 VPWR VGND VPWR VGND sky130_ef_sc_hd__decap_12
XFILLER_0_48_15 VPWR VGND VPWR VGND sky130_ef_sc_hd__decap_12
XFILLER_0_107_1077 VPWR VGND VPWR VGND sky130_ef_sc_hd__decap_12
XFILLER_0_139_39 VGND VGND VPWR VPWR sky130_fd_sc_hd__decap_8
XFILLER_0_218_1017 VPWR VGND VPWR VGND sky130_ef_sc_hd__decap_12
XFILLER_0_223_529 VPWR VGND VPWR VGND sky130_ef_sc_hd__decap_12
XFILLER_0_155_27 VPWR VGND VPWR VGND sky130_ef_sc_hd__decap_12
XFILLER_0_216_581 VGND VGND VPWR VPWR sky130_fd_sc_hd__decap_6
XFILLER_0_8_1213 VPWR VGND VPWR VGND sky130_ef_sc_hd__decap_12
XFILLER_0_176_617 VGND VGND VPWR VPWR sky130_fd_sc_hd__fill_1
XFILLER_0_114_1037 VPWR VGND VPWR VGND sky130_ef_sc_hd__decap_12
XFILLER_0_59_645 VGND VGND VPWR VPWR sky130_fd_sc_hd__fill_1
XFILLER_0_89_1213 VPWR VGND VPWR VGND sky130_ef_sc_hd__decap_12
XFILLER_0_104_53 VGND VGND VPWR VPWR sky130_fd_sc_hd__decap_3
XFILLER_0_7_937 VPWR VGND VPWR VGND sky130_ef_sc_hd__decap_12
XFILLER_0_104_97 VPWR VGND VPWR VGND sky130_ef_sc_hd__decap_12
XFILLER_0_89_1279 VPWR VGND VPWR VGND sky130_ef_sc_hd__decap_12
XFILLER_0_6_469 VGND VGND VPWR VPWR sky130_fd_sc_hd__decap_6
XFILLER_0_120_41 VGND VGND VPWR VPWR sky130_fd_sc_hd__decap_8
XFILLER_0_129_1291 VPWR VGND VPWR VGND sky130_ef_sc_hd__decap_12
XFILLER_0_113_945 VGND VGND VPWR VPWR sky130_fd_sc_hd__decap_6
XFILLER_0_73_6 VGND VGND VPWR VPWR sky130_fd_sc_hd__fill_2
XFILLER_0_112_433 VPWR VGND VPWR VGND sky130_ef_sc_hd__decap_12
XFILLER_0_199_1201 VPWR VGND VPWR VGND sky130_ef_sc_hd__decap_12
XFILLER_0_113_989 VPWR VGND VPWR VGND sky130_ef_sc_hd__decap_12
XFILLER_0_100_617 VGND VGND VPWR VPWR sky130_fd_sc_hd__fill_1
XFILLER_0_112_477 VPWR VGND VPWR VGND sky130_ef_sc_hd__decap_12
XFILLER_0_26_1263 VPWR VGND VPWR VGND sky130_ef_sc_hd__decap_12
XFILLER_0_199_1267 VPWR VGND VPWR VGND sky130_ef_sc_hd__decap_12
XFILLER_0_96_1239 VPWR VGND VPWR VGND sky130_ef_sc_hd__decap_12
XFILLER_0_210_713 VPWR VGND VPWR VGND sky130_ef_sc_hd__decap_12
XFILLER_0_136_1251 VPWR VGND VPWR VGND sky130_ef_sc_hd__decap_12
XFILLER_0_136_1295 VPWR VGND VPWR VGND sky130_ef_sc_hd__decap_12
XFILLER_0_167_617 VPWR VGND VPWR VGND sky130_ef_sc_hd__decap_12
XFILLER_0_33_1201 VPWR VGND VPWR VGND sky130_ef_sc_hd__decap_12
XFILLER_0_210_757 VPWR VGND VPWR VGND sky130_ef_sc_hd__decap_12
XPHY_916 VGND VGND VPWR VPWR sky130_fd_sc_hd__decap_3
XPHY_905 VGND VGND VPWR VPWR sky130_fd_sc_hd__decap_3
XFILLER_0_72_1283 VPWR VGND VPWR VGND sky130_ef_sc_hd__decap_12
XPHY_927 VGND VGND VPWR VPWR sky130_fd_sc_hd__decap_3
XFILLER_0_212_1161 VPWR VGND VPWR VGND sky130_ef_sc_hd__decap_12
XPHY_949 VGND VGND VPWR VPWR sky130_fd_sc_hd__decap_3
XFILLER_0_33_1267 VPWR VGND VPWR VGND sky130_ef_sc_hd__decap_12
XPHY_938 VGND VGND VPWR VPWR sky130_fd_sc_hd__decap_3
XFILLER_0_190_631 VPWR VGND VPWR VGND sky130_ef_sc_hd__decap_12
XFILLER_0_68_1319 VPWR VGND VPWR VGND sky130_ef_sc_hd__decap_12
XFILLER_0_107_205 VPWR VGND VPWR VGND sky130_ef_sc_hd__decap_12
XFILLER_0_107_249 VPWR VGND VPWR VGND sky130_ef_sc_hd__decap_12
XFILLER_0_6_981 VPWR VGND VPWR VGND sky130_ef_sc_hd__decap_12
XFILLER_0_143_1255 VPWR VGND VPWR VGND sky130_ef_sc_hd__decap_12
XFILLER_0_218_813 VPWR VGND VPWR VGND sky130_ef_sc_hd__decap_12
XFILLER_0_104_1217 VPWR VGND VPWR VGND sky130_ef_sc_hd__decap_12
XFILLER_0_178_1307 VPWR VGND VPWR VGND sky130_ef_sc_hd__decap_12
XFILLER_0_40_1227 VPWR VGND VPWR VGND sky130_ef_sc_hd__decap_12
XFILLER_0_18_29 VPWR VGND VPWR VGND sky130_ef_sc_hd__decap_12
XFILLER_0_219_1337 VGND VGND VPWR VPWR sky130_fd_sc_hd__decap_6
XTAP_2320 VGND VPWR sky130_fd_sc_hd__tapvpwrvgnd_1
XFILLER_0_213_573 VPWR VGND VPWR VGND sky130_ef_sc_hd__decap_12
XTAP_2331 VGND VPWR sky130_fd_sc_hd__tapvpwrvgnd_1
XFILLER_0_115_1335 VGND VGND VPWR VPWR sky130_fd_sc_hd__decap_8
XTAP_2342 VGND VPWR sky130_fd_sc_hd__tapvpwrvgnd_1
XFILLER_0_158_617 VGND VGND VPWR VPWR sky130_fd_sc_hd__fill_1
XTAP_2353 VGND VPWR sky130_fd_sc_hd__tapvpwrvgnd_1
XTAP_2386 VGND VPWR sky130_fd_sc_hd__tapvpwrvgnd_1
XTAP_2375 VGND VPWR sky130_fd_sc_hd__tapvpwrvgnd_1
XTAP_2364 VGND VPWR sky130_fd_sc_hd__tapvpwrvgnd_1
XTAP_1630 VGND VPWR sky130_fd_sc_hd__tapvpwrvgnd_1
XFILLER_0_51_1323 VPWR VGND VPWR VGND sky130_ef_sc_hd__decap_12
XTAP_1641 VGND VPWR sky130_fd_sc_hd__tapvpwrvgnd_1
XTAP_2397 VGND VPWR sky130_fd_sc_hd__tapvpwrvgnd_1
XTAP_1685 VGND VPWR sky130_fd_sc_hd__tapvpwrvgnd_1
XTAP_1674 VGND VPWR sky130_fd_sc_hd__tapvpwrvgnd_1
XFILLER_0_3_1121 VPWR VGND VPWR VGND sky130_ef_sc_hd__decap_12
XFILLER_0_12_1307 VPWR VGND VPWR VGND sky130_ef_sc_hd__decap_12
XTAP_1652 VGND VPWR sky130_fd_sc_hd__tapvpwrvgnd_1
XTAP_1663 VGND VPWR sky130_fd_sc_hd__tapvpwrvgnd_1
XFILLER_0_50_49 VGND VGND VPWR VPWR sky130_fd_sc_hd__fill_1
XFILLER_0_50_27 VGND VGND VPWR VPWR sky130_fd_sc_hd__fill_1
XTAP_1696 VGND VPWR sky130_fd_sc_hd__tapvpwrvgnd_1
XFILLER_0_221_51 VGND VGND VPWR VPWR sky130_fd_sc_hd__decap_4
XFILLER_0_71_629 VPWR VGND VPWR VGND sky130_ef_sc_hd__decap_12
XFILLER_0_107_783 VGND VGND VPWR VPWR sky130_fd_sc_hd__fill_1
XFILLER_0_3_417 VPWR VGND VPWR VGND sky130_ef_sc_hd__decap_12
XFILLER_0_161_1311 VPWR VGND VPWR VGND sky130_ef_sc_hd__decap_12
XFILLER_0_59_25 VPWR VGND VPWR VGND sky130_ef_sc_hd__decap_12
XANTENNA_u_pe00_act_in[0] net1 VGND VGND VPWR VPWR sky130_fd_sc_hd__diode_2
XFILLER_0_122_1339 VGND VGND VPWR VPWR sky130_fd_sc_hd__decap_4
XFILLER_0_110_937 VPWR VGND VPWR VGND sky130_ef_sc_hd__decap_12
XFILLER_0_166_15 VPWR VGND VPWR VGND sky130_ef_sc_hd__decap_12
XFILLER_0_224_805 VGND VGND VPWR VPWR sky130_fd_sc_hd__decap_6
XFILLER_0_38_9 VGND VGND VPWR VPWR sky130_fd_sc_hd__fill_2
XFILLER_0_224_849 VPWR VGND VPWR VGND sky130_ef_sc_hd__decap_12
XFILLER_0_223_337 VPWR VGND VPWR VGND sky130_ef_sc_hd__decap_12
XFILLER_0_56_1201 VPWR VGND VPWR VGND sky130_ef_sc_hd__decap_12
XFILLER_0_182_25 VGND VGND VPWR VPWR sky130_fd_sc_hd__decap_3
XFILLER_0_149_617 VPWR VGND VPWR VGND sky130_ef_sc_hd__decap_12
XFILLER_0_91_34 VPWR VGND VPWR VGND sky130_ef_sc_hd__decap_12
XFILLER_0_7_701 VPWR VGND VPWR VGND sky130_ef_sc_hd__decap_12
XFILLER_0_172_631 VPWR VGND VPWR VGND sky130_ef_sc_hd__decap_12
XFILLER_0_105_709 VPWR VGND VPWR VGND sky130_ef_sc_hd__decap_12
XFILLER_0_6_233 VPWR VGND VPWR VGND sky130_ef_sc_hd__decap_12
XFILLER_0_6_277 VPWR VGND VPWR VGND sky130_ef_sc_hd__decap_12
XFILLER_0_113_753 VPWR VGND VPWR VGND sky130_ef_sc_hd__decap_12
XFILLER_0_3_951 VGND VGND VPWR VPWR sky130_fd_sc_hd__fill_1
XFILLER_0_71_3 VPWR VGND VPWR VGND sky130_ef_sc_hd__decap_12
XFILLER_0_63_1249 VGND VGND VPWR VPWR sky130_fd_sc_hd__decap_4
XFILLER_0_113_797 VPWR VGND VPWR VGND sky130_ef_sc_hd__decap_12
Xoutput220 net220 VGND VGND VPWR VPWR psum_col1_out[30] sky130_fd_sc_hd__clkbuf_4
XFILLER_0_218_109 VPWR VGND VPWR VGND sky130_ef_sc_hd__decap_12
XFILLER_0_226_120 VPWR VGND VPWR VGND sky130_ef_sc_hd__decap_12
XFILLER_0_226_153 VGND VGND VPWR VPWR sky130_fd_sc_hd__fill_2
XFILLER_0_226_197 VGND VGND VPWR VPWR sky130_fd_sc_hd__fill_2
XFILLER_0_226_29 VPWR VGND VPWR VGND sky130_ef_sc_hd__decap_12
XFILLER_0_173_1237 VPWR VGND VPWR VGND sky130_ef_sc_hd__decap_12
XPHY_702 VGND VGND VPWR VPWR sky130_fd_sc_hd__decap_3
XPHY_713 VGND VGND VPWR VPWR sky130_fd_sc_hd__decap_3
XPHY_724 VGND VGND VPWR VPWR sky130_fd_sc_hd__decap_3
XPHY_735 VGND VGND VPWR VPWR sky130_fd_sc_hd__decap_3
XPHY_768 VGND VGND VPWR VPWR sky130_fd_sc_hd__decap_3
XPHY_757 VGND VGND VPWR VPWR sky130_fd_sc_hd__decap_3
XFILLER_0_108_525 VGND VGND VPWR VPWR sky130_fd_sc_hd__decap_6
XPHY_746 VGND VGND VPWR VPWR sky130_fd_sc_hd__decap_3
XPHY_779 VGND VGND VPWR VPWR sky130_fd_sc_hd__decap_3
XFILLER_0_53_629 VPWR VGND VPWR VGND sky130_ef_sc_hd__decap_12
XFILLER_0_108_569 VPWR VGND VPWR VGND sky130_ef_sc_hd__decap_12
XFILLER_0_104_753 VGND VGND VPWR VPWR sky130_fd_sc_hd__decap_3
XFILLER_0_108_1161 VPWR VGND VPWR VGND sky130_ef_sc_hd__decap_12
XFILLER_0_104_797 VPWR VGND VPWR VGND sky130_ef_sc_hd__decap_12
XANTENNA_input55_A psum_col0_in[29] VGND VGND VPWR VPWR sky130_fd_sc_hd__diode_2
XFILLER_0_29_39 VGND VGND VPWR VPWR sky130_fd_sc_hd__decap_8
XFILLER_0_218_643 VGND VGND VPWR VPWR sky130_fd_sc_hd__fill_1
XFILLER_0_79_1201 VPWR VGND VPWR VGND sky130_ef_sc_hd__decap_12
XFILLER_0_219_1101 VPWR VGND VPWR VGND sky130_ef_sc_hd__decap_12
XFILLER_0_219_1145 VPWR VGND VPWR VGND sky130_ef_sc_hd__decap_12
XFILLER_0_79_1267 VPWR VGND VPWR VGND sky130_ef_sc_hd__decap_12
XFILLER_0_136_29 VPWR VGND VPWR VGND sky130_ef_sc_hd__decap_12
XFILLER_0_219_1189 VPWR VGND VPWR VGND sky130_ef_sc_hd__decap_12
XFILLER_0_215_1009 VPWR VGND VPWR VGND sky130_ef_sc_hd__decap_12
XFILLER_0_220_307 VGND VGND VPWR VPWR sky130_fd_sc_hd__fill_1
XFILLER_0_214_893 VPWR VGND VPWR VGND sky130_ef_sc_hd__decap_12
XANTENNA_output211_A net211 VGND VGND VPWR VPWR sky130_fd_sc_hd__diode_2
XTAP_2150 VGND VPWR sky130_fd_sc_hd__tapvpwrvgnd_1
XFILLER_0_61_15 VPWR VGND VPWR VGND sky130_ef_sc_hd__decap_12
XTAP_2161 VGND VPWR sky130_fd_sc_hd__tapvpwrvgnd_1
XTAP_2183 VGND VPWR sky130_fd_sc_hd__tapvpwrvgnd_1
XTAP_2172 VGND VPWR sky130_fd_sc_hd__tapvpwrvgnd_1
XFILLER_0_111_1007 VGND VGND VPWR VPWR sky130_fd_sc_hd__fill_1
XTAP_2194 VGND VPWR sky130_fd_sc_hd__tapvpwrvgnd_1
XTAP_1460 VGND VPWR sky130_fd_sc_hd__tapvpwrvgnd_1
XFILLER_0_16_1251 VPWR VGND VPWR VGND sky130_ef_sc_hd__decap_12
XFILLER_0_189_1255 VPWR VGND VPWR VGND sky130_ef_sc_hd__decap_12
XTAP_1493 VGND VPWR sky130_fd_sc_hd__tapvpwrvgnd_1
XTAP_1482 VGND VPWR sky130_fd_sc_hd__tapvpwrvgnd_1
XTAP_1471 VGND VPWR sky130_fd_sc_hd__tapvpwrvgnd_1
XFILLER_0_16_1295 VPWR VGND VPWR VGND sky130_ef_sc_hd__decap_12
XFILLER_0_154_631 VPWR VGND VPWR VGND sky130_ef_sc_hd__decap_12
XFILLER_0_114_517 VPWR VGND VPWR VGND sky130_ef_sc_hd__decap_12
XFILLER_0_9_27 VPWR VGND VPWR VGND sky130_ef_sc_hd__decap_12
XFILLER_0_86_1227 VPWR VGND VPWR VGND sky130_ef_sc_hd__decap_12
XFILLER_0_101_10 VPWR VGND VPWR VGND sky130_ef_sc_hd__decap_12
XFILLER_0_3_225 VPWR VGND VPWR VGND sky130_ef_sc_hd__decap_12
XFILLER_0_4_737 VPWR VGND VPWR VGND sky130_ef_sc_hd__decap_12
XFILLER_0_10_41 VGND VGND VPWR VPWR sky130_fd_sc_hd__decap_8
XFILLER_0_110_701 VPWR VGND VPWR VGND sky130_ef_sc_hd__decap_12
XFILLER_0_177_47 VGND VGND VPWR VPWR sky130_fd_sc_hd__fill_1
XFILLER_0_126_1283 VPWR VGND VPWR VGND sky130_ef_sc_hd__decap_12
XFILLER_0_23_1255 VPWR VGND VPWR VGND sky130_ef_sc_hd__decap_12
XFILLER_0_224_613 VPWR VGND VPWR VGND sky130_ef_sc_hd__decap_12
XFILLER_0_97_1323 VPWR VGND VPWR VGND sky130_ef_sc_hd__decap_12
XFILLER_0_58_1307 VPWR VGND VPWR VGND sky130_ef_sc_hd__decap_12
XFILLER_0_224_657 VPWR VGND VPWR VGND sky130_ef_sc_hd__decap_12
XFILLER_0_223_167 VGND VGND VPWR VPWR sky130_fd_sc_hd__fill_1
XFILLER_0_211_329 VGND VGND VPWR VPWR sky130_fd_sc_hd__decap_6
XFILLER_0_172_1281 VGND VGND VPWR VPWR sky130_fd_sc_hd__fill_1
XFILLER_0_168_1339 VGND VGND VPWR VPWR sky130_fd_sc_hd__decap_4
XFILLER_0_35_629 VPWR VGND VPWR VGND sky130_ef_sc_hd__decap_12
XFILLER_0_209_1303 VGND VGND VPWR VPWR sky130_fd_sc_hd__decap_6
XFILLER_0_105_517 VPWR VGND VPWR VGND sky130_ef_sc_hd__decap_12
XFILLER_0_105_1301 VPWR VGND VPWR VGND sky130_ef_sc_hd__decap_12
XFILLER_0_113_561 VPWR VGND VPWR VGND sky130_ef_sc_hd__decap_12
XFILLER_0_219_429 VPWR VGND VPWR VGND sky130_ef_sc_hd__decap_12
XFILLER_0_140_1225 VGND VGND VPWR VPWR sky130_fd_sc_hd__fill_1
XFILLER_0_41_1311 VPWR VGND VPWR VGND sky130_ef_sc_hd__decap_12
XFILLER_0_216_1329 VPWR VGND VPWR VGND sky130_ef_sc_hd__decap_12
XFILLER_0_214_189 VGND VGND VPWR VPWR sky130_fd_sc_hd__decap_6
XFILLER_0_211_841 VPWR VGND VPWR VGND sky130_ef_sc_hd__decap_12
XFILLER_0_151_1343 VGND VGND VPWR VPWR sky130_fd_sc_hd__fill_1
XPHY_510 VGND VGND VPWR VPWR sky130_fd_sc_hd__decap_3
XPHY_543 VGND VGND VPWR VPWR sky130_fd_sc_hd__decap_3
XPHY_521 VGND VGND VPWR VPWR sky130_fd_sc_hd__decap_3
XPHY_532 VGND VGND VPWR VPWR sky130_fd_sc_hd__decap_3
XPHY_1120 VGND VGND VPWR VPWR sky130_fd_sc_hd__decap_3
XPHY_1131 VGND VGND VPWR VPWR sky130_fd_sc_hd__decap_3
XPHY_554 VGND VGND VPWR VPWR sky130_fd_sc_hd__decap_3
XFILLER_0_136_631 VPWR VGND VPWR VGND sky130_ef_sc_hd__decap_12
XPHY_576 VGND VGND VPWR VPWR sky130_fd_sc_hd__decap_3
XPHY_565 VGND VGND VPWR VPWR sky130_fd_sc_hd__decap_3
XPHY_587 VGND VGND VPWR VPWR sky130_fd_sc_hd__decap_3
XFILLER_0_108_333 VPWR VGND VPWR VGND sky130_ef_sc_hd__decap_12
XPHY_1164 VGND VGND VPWR VPWR sky130_fd_sc_hd__decap_3
XPHY_1153 VGND VGND VPWR VPWR sky130_fd_sc_hd__decap_3
XPHY_1175 VGND VGND VPWR VPWR sky130_fd_sc_hd__decap_3
XPHY_1142 VGND VGND VPWR VPWR sky130_fd_sc_hd__decap_3
XFILLER_0_110_1073 VPWR VGND VPWR VGND sky130_ef_sc_hd__decap_12
XFILLER_0_109_889 VGND VGND VPWR VPWR sky130_fd_sc_hd__decap_6
XPHY_598 VGND VGND VPWR VPWR sky130_fd_sc_hd__decap_3
XFILLER_0_108_377 VPWR VGND VPWR VGND sky130_ef_sc_hd__decap_12
XPHY_1197 VGND VGND VPWR VPWR sky130_fd_sc_hd__decap_3
XPHY_1186 VGND VGND VPWR VPWR sky130_fd_sc_hd__decap_3
XFILLER_0_151_645 VGND VGND VPWR VPWR sky130_fd_sc_hd__fill_1
XFILLER_0_104_561 VPWR VGND VPWR VGND sky130_ef_sc_hd__decap_12
XFILLER_0_1_729 VPWR VGND VPWR VGND sky130_ef_sc_hd__decap_12
XFILLER_0_221_1057 VGND VGND VPWR VPWR sky130_fd_sc_hd__decap_6
XFILLER_0_163_27 VPWR VGND VPWR VGND sky130_ef_sc_hd__decap_12
XFILLER_0_117_1249 VGND VGND VPWR VPWR sky130_fd_sc_hd__decap_4
XFILLER_0_92_1275 VGND VGND VPWR VPWR sky130_fd_sc_hd__decap_6
XFILLER_0_53_1237 VPWR VGND VPWR VGND sky130_ef_sc_hd__decap_12
XFILLER_0_5_1057 VGND VGND VPWR VPWR sky130_fd_sc_hd__decap_6
XTAP_1290 VGND VPWR sky130_fd_sc_hd__tapvpwrvgnd_1
XFILLER_0_17_629 VPWR VGND VPWR VGND sky130_ef_sc_hd__decap_12
XFILLER_0_4_501 VPWR VGND VPWR VGND sky130_ef_sc_hd__decap_12
XFILLER_0_112_53 VPWR VGND VPWR VGND sky130_ef_sc_hd__decap_12
XFILLER_0_163_1225 VPWR VGND VPWR VGND sky130_ef_sc_hd__decap_12
XFILLER_0_4_545 VPWR VGND VPWR VGND sky130_ef_sc_hd__decap_12
XFILLER_0_112_97 VPWR VGND VPWR VGND sky130_ef_sc_hd__decap_12
XFILLER_0_4_589 VPWR VGND VPWR VGND sky130_ef_sc_hd__decap_12
XFILLER_0_40_643 VPWR VGND VPWR VGND sky130_ef_sc_hd__decap_12
XFILLER_0_110_531 VGND VGND VPWR VPWR sky130_fd_sc_hd__fill_1
XFILLER_0_225_933 VPWR VGND VPWR VGND sky130_ef_sc_hd__decap_12
XFILLER_0_224_421 VPWR VGND VPWR VGND sky130_ef_sc_hd__decap_12
XFILLER_0_34_3 VPWR VGND VPWR VGND sky130_ef_sc_hd__decap_12
XFILLER_0_225_977 VPWR VGND VPWR VGND sky130_ef_sc_hd__decap_12
XFILLER_0_174_1343 VGND VGND VPWR VPWR sky130_fd_sc_hd__fill_1
XFILLER_0_100_1275 VGND VGND VPWR VPWR sky130_fd_sc_hd__decap_6
XTAP_2919 VGND VPWR sky130_fd_sc_hd__tapvpwrvgnd_1
XTAP_2908 VGND VPWR sky130_fd_sc_hd__tapvpwrvgnd_1
XFILLER_0_211_137 VPWR VGND VPWR VGND sky130_ef_sc_hd__decap_12
XFILLER_0_220_693 VGND VGND VPWR VPWR sky130_fd_sc_hd__decap_6
XFILLER_0_118_631 VPWR VGND VPWR VGND sky130_ef_sc_hd__decap_12
XFILLER_0_181_1303 VGND VGND VPWR VPWR sky130_fd_sc_hd__decap_6
XFILLER_0_106_837 VPWR VGND VPWR VGND sky130_ef_sc_hd__decap_12
XFILLER_0_7_361 VGND VGND VPWR VPWR sky130_fd_sc_hd__decap_3
XFILLER_0_69_1255 VPWR VGND VPWR VGND sky130_ef_sc_hd__decap_12
XFILLER_0_133_645 VGND VGND VPWR VPWR sky130_fd_sc_hd__fill_1
XFILLER_0_114_881 VPWR VGND VPWR VGND sky130_ef_sc_hd__decap_12
XFILLER_0_113_391 VGND VGND VPWR VPWR sky130_fd_sc_hd__fill_1
XFILLER_0_219_237 VPWR VGND VPWR VGND sky130_ef_sc_hd__decap_12
XANTENNA_input157_A w11[2] VGND VGND VPWR VPWR sky130_fd_sc_hd__diode_2
XFILLER_0_105_1175 VGND VGND VPWR VPWR sky130_fd_sc_hd__fill_1
XFILLER_0_26_29 VPWR VGND VPWR VGND sky130_ef_sc_hd__decap_12
XFILLER_0_203_605 VPWR VGND VPWR VGND sky130_ef_sc_hd__decap_12
XFILLER_0_98_643 VPWR VGND VPWR VGND sky130_ef_sc_hd__decap_12
XANTENNA_input18_A act_row1_in[10] VGND VGND VPWR VPWR sky130_fd_sc_hd__diode_2
XFILLER_0_211_671 VGND VGND VPWR VPWR sky130_fd_sc_hd__fill_1
XFILLER_0_210_181 VPWR VGND VPWR VGND sky130_ef_sc_hd__decap_12
XPHY_340 VGND VGND VPWR VPWR sky130_fd_sc_hd__decap_3
XFILLER_0_52_1281 VGND VGND VPWR VPWR sky130_fd_sc_hd__fill_1
XPHY_351 VGND VGND VPWR VPWR sky130_fd_sc_hd__decap_3
XFILLER_0_186_1225 VGND VGND VPWR VPWR sky130_fd_sc_hd__fill_1
XFILLER_0_213_9 VGND VGND VPWR VPWR sky130_fd_sc_hd__fill_2
XFILLER_0_109_653 VPWR VGND VPWR VGND sky130_ef_sc_hd__decap_12
XPHY_395 VGND VGND VPWR VPWR sky130_fd_sc_hd__decap_3
XPHY_373 VGND VGND VPWR VPWR sky130_fd_sc_hd__decap_3
XPHY_384 VGND VGND VPWR VPWR sky130_fd_sc_hd__decap_3
XPHY_362 VGND VGND VPWR VPWR sky130_fd_sc_hd__decap_3
XFILLER_0_87_1311 VPWR VGND VPWR VGND sky130_ef_sc_hd__decap_12
XFILLER_0_108_141 VPWR VGND VPWR VGND sky130_ef_sc_hd__decap_12
XFILLER_0_109_697 VPWR VGND VPWR VGND sky130_ef_sc_hd__decap_12
XFILLER_0_48_1339 VGND VGND VPWR VPWR sky130_fd_sc_hd__decap_4
XFILLER_0_223_1119 VGND VGND VPWR VPWR sky130_fd_sc_hd__fill_1
XFILLER_0_22_643 VPWR VGND VPWR VGND sky130_ef_sc_hd__decap_12
XFILLER_0_111_317 VPWR VGND VPWR VGND sky130_ef_sc_hd__decap_12
XFILLER_0_1_559 VGND VGND VPWR VPWR sky130_fd_sc_hd__fill_1
XFILLER_0_158_27 VGND VGND VPWR VPWR sky130_fd_sc_hd__fill_1
XFILLER_0_123_1253 VGND VGND VPWR VPWR sky130_fd_sc_hd__fill_1
XFILLER_0_67_47 VGND VGND VPWR VPWR sky130_fd_sc_hd__decap_3
XFILLER_0_158_49 VGND VGND VPWR VPWR sky130_fd_sc_hd__fill_1
XFILLER_0_20_1225 VGND VGND VPWR VPWR sky130_fd_sc_hd__fill_1
XFILLER_0_177_3 VPWR VGND VPWR VGND sky130_ef_sc_hd__decap_12
XFILLER_0_94_1337 VGND VGND VPWR VPWR sky130_fd_sc_hd__fill_1
XFILLER_0_174_15 VPWR VGND VPWR VGND sky130_ef_sc_hd__decap_12
XFILLER_0_222_925 VPWR VGND VPWR VGND sky130_ef_sc_hd__decap_12
XFILLER_0_130_1213 VPWR VGND VPWR VGND sky130_ef_sc_hd__decap_12
XFILLER_0_31_1343 VGND VGND VPWR VPWR sky130_fd_sc_hd__fill_1
XFILLER_0_165_1309 VGND VGND VPWR VPWR sky130_fd_sc_hd__fill_1
XFILLER_0_5_821 VPWR VGND VPWR VGND sky130_ef_sc_hd__decap_12
XFILLER_0_115_645 VGND VGND VPWR VPWR sky130_fd_sc_hd__fill_1
XFILLER_0_5_865 VPWR VGND VPWR VGND sky130_ef_sc_hd__decap_12
XFILLER_0_206_1339 VGND VGND VPWR VPWR sky130_fd_sc_hd__decap_4
XFILLER_0_102_1337 VGND VGND VPWR VPWR sky130_fd_sc_hd__fill_1
XFILLER_0_99_1237 VPWR VGND VPWR VGND sky130_ef_sc_hd__decap_12
XFILLER_0_111_895 VGND VGND VPWR VPWR sky130_fd_sc_hd__fill_1
XFILLER_0_0_581 VGND VGND VPWR VPWR sky130_fd_sc_hd__decap_6
XFILLER_0_225_741 VPWR VGND VPWR VGND sky130_ef_sc_hd__decap_12
XFILLER_0_225_785 VPWR VGND VPWR VGND sky130_ef_sc_hd__decap_12
XFILLER_0_224_251 VGND VGND VPWR VPWR sky130_fd_sc_hd__fill_1
XFILLER_0_212_413 VGND VGND VPWR VPWR sky130_fd_sc_hd__decap_6
XTAP_2705 VGND VPWR sky130_fd_sc_hd__tapvpwrvgnd_1
XTAP_2727 VGND VPWR sky130_fd_sc_hd__tapvpwrvgnd_1
XTAP_2716 VGND VPWR sky130_fd_sc_hd__tapvpwrvgnd_1
XTAP_2749 VGND VPWR sky130_fd_sc_hd__tapvpwrvgnd_1
XFILLER_0_200_619 VPWR VGND VPWR VGND sky130_ef_sc_hd__decap_12
XTAP_2738 VGND VPWR sky130_fd_sc_hd__tapvpwrvgnd_1
XFILLER_0_212_457 VPWR VGND VPWR VGND sky130_ef_sc_hd__decap_12
XFILLER_0_211_1001 VGND VGND VPWR VPWR sky130_fd_sc_hd__decap_6
XFILLER_0_211_1045 VPWR VGND VPWR VGND sky130_ef_sc_hd__decap_12
XFILLER_0_211_1089 VPWR VGND VPWR VGND sky130_ef_sc_hd__decap_12
XFILLER_0_106_601 VPWR VGND VPWR VGND sky130_ef_sc_hd__decap_12
XFILLER_0_106_645 VPWR VGND VPWR VGND sky130_ef_sc_hd__decap_12
XFILLER_0_105_111 VGND VGND VPWR VPWR sky130_fd_sc_hd__fill_1
XFILLER_0_185_1291 VPWR VGND VPWR VGND sky130_ef_sc_hd__decap_12
XFILLER_0_146_1275 VGND VGND VPWR VPWR sky130_fd_sc_hd__decap_6
XFILLER_0_82_1263 VPWR VGND VPWR VGND sky130_ef_sc_hd__decap_12
XFILLER_0_222_1141 VGND VGND VPWR VPWR sky130_fd_sc_hd__decap_6
XFILLER_0_43_1225 VPWR VGND VPWR VGND sky130_ef_sc_hd__decap_12
XFILLER_0_222_1185 VPWR VGND VPWR VGND sky130_ef_sc_hd__decap_12
Xinput120 w01[12] VGND VGND VPWR VPWR net120 sky130_fd_sc_hd__clkbuf_4
XFILLER_0_37_39 VGND VGND VPWR VPWR sky130_fd_sc_hd__decap_8
Xinput153 w11[13] VGND VGND VPWR VPWR net153 sky130_fd_sc_hd__clkbuf_8
XFILLER_0_208_41 VGND VGND VPWR VPWR sky130_fd_sc_hd__decap_8
Xinput142 w10[3] VGND VGND VPWR VPWR net142 sky130_fd_sc_hd__clkbuf_4
Xinput131 w01[8] VGND VGND VPWR VPWR net131 sky130_fd_sc_hd__buf_4
Xinput164 w11[9] VGND VGND VPWR VPWR net164 sky130_fd_sc_hd__clkbuf_8
XFILLER_0_215_273 VGND VGND VPWR VPWR sky130_fd_sc_hd__decap_6
XFILLER_0_192_1251 VPWR VGND VPWR VGND sky130_ef_sc_hd__decap_12
XFILLER_0_153_1213 VPWR VGND VPWR VGND sky130_ef_sc_hd__decap_12
XFILLER_0_53_27 VPWR VGND VPWR VGND sky130_ef_sc_hd__decap_12
XFILLER_0_144_29 VPWR VGND VPWR VGND sky130_ef_sc_hd__decap_12
XFILLER_0_192_1295 VPWR VGND VPWR VGND sky130_ef_sc_hd__decap_12
XFILLER_0_54_1343 VGND VGND VPWR VPWR sky130_fd_sc_hd__fill_1
XFILLER_0_153_1279 VPWR VGND VPWR VGND sky130_ef_sc_hd__decap_12
XFILLER_0_2_1005 VPWR VGND VPWR VGND sky130_ef_sc_hd__decap_12
XFILLER_0_6_1141 VGND VGND VPWR VPWR sky130_fd_sc_hd__decap_6
XFILLER_0_6_1185 VPWR VGND VPWR VGND sky130_ef_sc_hd__decap_12
XPHY_170 VGND VGND VPWR VPWR sky130_fd_sc_hd__decap_3
XPHY_181 VGND VGND VPWR VPWR sky130_fd_sc_hd__decap_3
XPHY_192 VGND VGND VPWR VPWR sky130_fd_sc_hd__decap_3
XFILLER_0_2_1049 VPWR VGND VPWR VGND sky130_ef_sc_hd__decap_12
XFILLER_0_109_461 VPWR VGND VPWR VGND sky130_ef_sc_hd__decap_12
XFILLER_0_164_1331 VGND VGND VPWR VPWR sky130_fd_sc_hd__decap_6
XFILLER_0_2_813 VPWR VGND VPWR VGND sky130_ef_sc_hd__decap_12
XFILLER_0_169_15 VPWR VGND VPWR VGND sky130_ef_sc_hd__decap_12
XFILLER_0_112_637 VGND VGND VPWR VPWR sky130_fd_sc_hd__decap_6
XFILLER_0_61_1303 VGND VGND VPWR VPWR sky130_fd_sc_hd__decap_6
XFILLER_0_111_125 VPWR VGND VPWR VGND sky130_ef_sc_hd__decap_12
XFILLER_0_160_1239 VPWR VGND VPWR VGND sky130_ef_sc_hd__decap_12
XFILLER_0_111_169 VPWR VGND VPWR VGND sky130_ef_sc_hd__decap_12
XFILLER_0_201_1225 VPWR VGND VPWR VGND sky130_ef_sc_hd__decap_12
XFILLER_0_226_505 VGND VGND VPWR VPWR sky130_fd_sc_hd__fill_2
XFILLER_0_185_25 VPWR VGND VPWR VGND sky130_ef_sc_hd__decap_12
XFILLER_0_118_41 VGND VGND VPWR VPWR sky130_fd_sc_hd__decap_8
XFILLER_0_98_1281 VGND VGND VPWR VPWR sky130_fd_sc_hd__fill_1
XFILLER_0_222_755 VGND VGND VPWR VPWR sky130_fd_sc_hd__fill_1
XFILLER_0_171_1335 VGND VGND VPWR VPWR sky130_fd_sc_hd__decap_8
XFILLER_0_132_1319 VPWR VGND VPWR VGND sky130_ef_sc_hd__decap_12
XFILLER_0_92_605 VPWR VGND VPWR VGND sky130_ef_sc_hd__decap_12
XFILLER_0_169_1253 VGND VGND VPWR VPWR sky130_fd_sc_hd__fill_1
XFILLER_0_66_1225 VGND VGND VPWR VPWR sky130_fd_sc_hd__fill_1
XFILLER_0_5_673 VPWR VGND VPWR VGND sky130_ef_sc_hd__decap_12
XFILLER_0_217_505 VPWR VGND VPWR VGND sky130_ef_sc_hd__decap_12
XFILLER_0_176_1213 VPWR VGND VPWR VGND sky130_ef_sc_hd__decap_12
XTAP_2502 VGND VPWR sky130_fd_sc_hd__tapvpwrvgnd_1
XFILLER_0_212_221 VPWR VGND VPWR VGND sky130_ef_sc_hd__decap_12
XFILLER_0_217_1287 VGND VGND VPWR VPWR sky130_fd_sc_hd__fill_1
XFILLER_0_213_777 VGND VGND VPWR VPWR sky130_fd_sc_hd__decap_6
XTAP_2535 VGND VPWR sky130_fd_sc_hd__tapvpwrvgnd_1
XTAP_2524 VGND VPWR sky130_fd_sc_hd__tapvpwrvgnd_1
XTAP_2513 VGND VPWR sky130_fd_sc_hd__tapvpwrvgnd_1
XTAP_2557 VGND VPWR sky130_fd_sc_hd__tapvpwrvgnd_1
XTAP_2546 VGND VPWR sky130_fd_sc_hd__tapvpwrvgnd_1
XTAP_2579 VGND VPWR sky130_fd_sc_hd__tapvpwrvgnd_1
XFILLER_0_185_629 VPWR VGND VPWR VGND sky130_ef_sc_hd__decap_12
XFILLER_0_212_265 VPWR VGND VPWR VGND sky130_ef_sc_hd__decap_12
XTAP_2568 VGND VPWR sky130_fd_sc_hd__tapvpwrvgnd_1
XTAP_1823 VGND VPWR sky130_fd_sc_hd__tapvpwrvgnd_1
XTAP_1812 VGND VPWR sky130_fd_sc_hd__tapvpwrvgnd_1
XTAP_1801 VGND VPWR sky130_fd_sc_hd__tapvpwrvgnd_1
XTAP_1834 VGND VPWR sky130_fd_sc_hd__tapvpwrvgnd_1
XTAP_1867 VGND VPWR sky130_fd_sc_hd__tapvpwrvgnd_1
XTAP_1856 VGND VPWR sky130_fd_sc_hd__tapvpwrvgnd_1
XFILLER_0_83_605 VPWR VGND VPWR VGND sky130_ef_sc_hd__decap_12
XTAP_1845 VGND VPWR sky130_fd_sc_hd__tapvpwrvgnd_1
XTAP_1878 VGND VPWR sky130_fd_sc_hd__tapvpwrvgnd_1
XFILLER_0_3_1325 VPWR VGND VPWR VGND sky130_ef_sc_hd__decap_12
XTAP_1889 VGND VPWR sky130_fd_sc_hd__tapvpwrvgnd_1
XFILLER_0_107_921 VPWR VGND VPWR VGND sky130_ef_sc_hd__decap_12
XFILLER_0_10_1213 VPWR VGND VPWR VGND sky130_ef_sc_hd__decap_12
XANTENNA_input85_A psum_col1_in[27] VGND VGND VPWR VPWR sky130_fd_sc_hd__diode_2
XFILLER_0_148_1337 VGND VGND VPWR VPWR sky130_fd_sc_hd__fill_1
XFILLER_0_107_965 VPWR VGND VPWR VGND sky130_ef_sc_hd__decap_12
XFILLER_0_224_1203 VGND VGND VPWR VPWR sky130_fd_sc_hd__fill_1
XFILLER_0_2_109 VPWR VGND VPWR VGND sky130_ef_sc_hd__decap_12
XFILLER_0_106_475 VGND VGND VPWR VPWR sky130_fd_sc_hd__fill_1
XFILLER_0_210_53 VGND VGND VPWR VPWR sky130_fd_sc_hd__decap_3
XFILLER_0_107_1001 VGND VGND VPWR VPWR sky130_fd_sc_hd__decap_6
XFILLER_0_45_1309 VGND VGND VPWR VPWR sky130_fd_sc_hd__fill_1
XFILLER_0_107_1045 VPWR VGND VPWR VGND sky130_ef_sc_hd__decap_12
XFILLER_0_120_1201 VPWR VGND VPWR VGND sky130_ef_sc_hd__decap_12
XFILLER_0_107_1089 VPWR VGND VPWR VGND sky130_ef_sc_hd__decap_12
XFILLER_0_48_49 VGND VGND VPWR VPWR sky130_fd_sc_hd__fill_1
XFILLER_0_48_27 VGND VGND VPWR VPWR sky130_fd_sc_hd__fill_1
XFILLER_0_219_51 VGND VGND VPWR VPWR sky130_fd_sc_hd__decap_4
XFILLER_0_218_1029 VGND VGND VPWR VPWR sky130_fd_sc_hd__decap_6
XFILLER_0_64_15 VPWR VGND VPWR VGND sky130_ef_sc_hd__decap_12
XFILLER_0_155_39 VGND VGND VPWR VPWR sky130_fd_sc_hd__decap_8
XFILLER_0_161_6 VGND VGND VPWR VPWR sky130_fd_sc_hd__fill_2
XFILLER_0_8_1225 VGND VGND VPWR VPWR sky130_fd_sc_hd__fill_1
XFILLER_0_114_1005 VGND VGND VPWR VPWR sky130_fd_sc_hd__decap_3
XFILLER_0_114_1049 VPWR VGND VPWR VGND sky130_ef_sc_hd__decap_12
XFILLER_0_74_605 VPWR VGND VPWR VGND sky130_ef_sc_hd__decap_12
XFILLER_0_89_1225 VPWR VGND VPWR VGND sky130_ef_sc_hd__decap_12
XFILLER_0_7_949 VGND VGND VPWR VPWR sky130_fd_sc_hd__decap_3
XFILLER_0_112_401 VPWR VGND VPWR VGND sky130_ef_sc_hd__decap_12
XFILLER_0_203_1309 VGND VGND VPWR VPWR sky130_fd_sc_hd__fill_1
XFILLER_0_199_1213 VPWR VGND VPWR VGND sky130_ef_sc_hd__decap_12
XFILLER_0_196_13 VPWR VGND VPWR VGND sky130_ef_sc_hd__decap_12
XFILLER_0_2_643 VGND VGND VPWR VPWR sky130_fd_sc_hd__fill_1
XFILLER_0_66_6 VGND VGND VPWR VPWR sky130_fd_sc_hd__fill_2
XFILLER_0_112_445 VPWR VGND VPWR VGND sky130_ef_sc_hd__decap_12
XFILLER_0_26_1275 VGND VGND VPWR VPWR sky130_fd_sc_hd__decap_6
XFILLER_0_65_1291 VPWR VGND VPWR VGND sky130_ef_sc_hd__decap_12
XFILLER_0_112_489 VPWR VGND VPWR VGND sky130_ef_sc_hd__decap_12
XFILLER_0_199_1279 VPWR VGND VPWR VGND sky130_ef_sc_hd__decap_12
XFILLER_0_207_593 VPWR VGND VPWR VGND sky130_ef_sc_hd__decap_12
XFILLER_0_210_725 VGND VGND VPWR VPWR sky130_fd_sc_hd__decap_3
XFILLER_0_136_1263 VPWR VGND VPWR VGND sky130_ef_sc_hd__decap_12
XFILLER_0_167_629 VPWR VGND VPWR VGND sky130_ef_sc_hd__decap_12
XFILLER_0_72_1251 VPWR VGND VPWR VGND sky130_ef_sc_hd__decap_12
XFILLER_0_210_769 VPWR VGND VPWR VGND sky130_ef_sc_hd__decap_12
XPHY_906 VGND VGND VPWR VPWR sky130_fd_sc_hd__decap_3
XPHY_917 VGND VGND VPWR VPWR sky130_fd_sc_hd__decap_3
XFILLER_0_65_605 VPWR VGND VPWR VGND sky130_ef_sc_hd__decap_12
XFILLER_0_33_1213 VPWR VGND VPWR VGND sky130_ef_sc_hd__decap_12
XFILLER_0_212_1173 VPWR VGND VPWR VGND sky130_ef_sc_hd__decap_12
XPHY_928 VGND VGND VPWR VPWR sky130_fd_sc_hd__decap_3
XFILLER_0_72_1295 VPWR VGND VPWR VGND sky130_ef_sc_hd__decap_12
XPHY_939 VGND VGND VPWR VPWR sky130_fd_sc_hd__decap_3
XFILLER_0_33_1279 VPWR VGND VPWR VGND sky130_ef_sc_hd__decap_12
XFILLER_0_107_217 VGND VGND VPWR VPWR sky130_fd_sc_hd__decap_6
XFILLER_0_190_643 VPWR VGND VPWR VGND sky130_ef_sc_hd__decap_12
XFILLER_0_80_619 VPWR VGND VPWR VGND sky130_ef_sc_hd__decap_12
XFILLER_0_143_1201 VPWR VGND VPWR VGND sky130_ef_sc_hd__decap_12
XFILLER_0_6_993 VPWR VGND VPWR VGND sky130_ef_sc_hd__decap_12
XFILLER_0_182_1283 VPWR VGND VPWR VGND sky130_ef_sc_hd__decap_12
XFILLER_0_44_1331 VGND VGND VPWR VPWR sky130_fd_sc_hd__decap_6
XFILLER_0_143_1267 VPWR VGND VPWR VGND sky130_ef_sc_hd__decap_12
XFILLER_0_104_1229 VGND VGND VPWR VPWR sky130_fd_sc_hd__decap_3
XFILLER_0_178_1319 VPWR VGND VPWR VGND sky130_ef_sc_hd__decap_12
XFILLER_0_218_825 VPWR VGND VPWR VGND sky130_ef_sc_hd__decap_12
XFILLER_0_218_869 VPWR VGND VPWR VGND sky130_ef_sc_hd__decap_12
XFILLER_0_217_335 VGND VGND VPWR VPWR sky130_fd_sc_hd__fill_1
XFILLER_0_40_1239 VPWR VGND VPWR VGND sky130_ef_sc_hd__decap_12
XFILLER_0_213_541 VPWR VGND VPWR VGND sky130_ef_sc_hd__decap_12
XTAP_2310 VGND VPWR sky130_fd_sc_hd__tapvpwrvgnd_1
XFILLER_0_213_585 VPWR VGND VPWR VGND sky130_ef_sc_hd__decap_12
XTAP_2343 VGND VPWR sky130_fd_sc_hd__tapvpwrvgnd_1
XTAP_2332 VGND VPWR sky130_fd_sc_hd__tapvpwrvgnd_1
XFILLER_0_115_1303 VGND VGND VPWR VPWR sky130_fd_sc_hd__decap_6
XFILLER_0_34_29 VPWR VGND VPWR VGND sky130_ef_sc_hd__decap_12
XTAP_2321 VGND VPWR sky130_fd_sc_hd__tapvpwrvgnd_1
XTAP_2387 VGND VPWR sky130_fd_sc_hd__tapvpwrvgnd_1
XTAP_2376 VGND VPWR sky130_fd_sc_hd__tapvpwrvgnd_1
XTAP_2365 VGND VPWR sky130_fd_sc_hd__tapvpwrvgnd_1
XFILLER_0_150_1227 VPWR VGND VPWR VGND sky130_ef_sc_hd__decap_12
XTAP_2354 VGND VPWR sky130_fd_sc_hd__tapvpwrvgnd_1
XFILLER_0_56_605 VPWR VGND VPWR VGND sky130_ef_sc_hd__decap_12
XTAP_1642 VGND VPWR sky130_fd_sc_hd__tapvpwrvgnd_1
XTAP_1620 VGND VPWR sky130_fd_sc_hd__tapvpwrvgnd_1
XTAP_1631 VGND VPWR sky130_fd_sc_hd__tapvpwrvgnd_1
XTAP_2398 VGND VPWR sky130_fd_sc_hd__tapvpwrvgnd_1
XTAP_1653 VGND VPWR sky130_fd_sc_hd__tapvpwrvgnd_1
XFILLER_0_12_1319 VPWR VGND VPWR VGND sky130_ef_sc_hd__decap_12
XFILLER_0_51_1335 VGND VGND VPWR VPWR sky130_fd_sc_hd__decap_8
XTAP_1664 VGND VPWR sky130_fd_sc_hd__tapvpwrvgnd_1
XTAP_1675 VGND VPWR sky130_fd_sc_hd__tapvpwrvgnd_1
XTAP_1686 VGND VPWR sky130_fd_sc_hd__tapvpwrvgnd_1
XFILLER_0_3_1133 VPWR VGND VPWR VGND sky130_ef_sc_hd__decap_12
XTAP_1697 VGND VPWR sky130_fd_sc_hd__tapvpwrvgnd_1
XFILLER_0_3_1177 VPWR VGND VPWR VGND sky130_ef_sc_hd__decap_12
XFILLER_0_3_429 VPWR VGND VPWR VGND sky130_ef_sc_hd__decap_12
XFILLER_0_49_1253 VGND VGND VPWR VPWR sky130_fd_sc_hd__fill_1
XFILLER_0_161_1323 VPWR VGND VPWR VGND sky130_ef_sc_hd__decap_12
XFILLER_0_110_905 VPWR VGND VPWR VGND sky130_ef_sc_hd__decap_12
XFILLER_0_59_37 VGND VGND VPWR VPWR sky130_fd_sc_hd__decap_8
XFILLER_0_122_1307 VPWR VGND VPWR VGND sky130_ef_sc_hd__decap_12
XFILLER_0_110_949 VPWR VGND VPWR VGND sky130_ef_sc_hd__decap_12
XFILLER_0_202_1331 VGND VGND VPWR VPWR sky130_fd_sc_hd__decap_6
XFILLER_0_166_27 VGND VGND VPWR VPWR sky130_fd_sc_hd__fill_1
XFILLER_0_166_49 VGND VGND VPWR VPWR sky130_fd_sc_hd__fill_1
XFILLER_0_223_305 VPWR VGND VPWR VGND sky130_ef_sc_hd__decap_12
XFILLER_0_75_47 VGND VGND VPWR VPWR sky130_fd_sc_hd__decap_3
XFILLER_0_223_349 VPWR VGND VPWR VGND sky130_ef_sc_hd__decap_12
XFILLER_0_56_1213 VPWR VGND VPWR VGND sky130_ef_sc_hd__decap_12
XFILLER_0_149_629 VPWR VGND VPWR VGND sky130_ef_sc_hd__decap_12
XFILLER_0_91_46 VGND VGND VPWR VPWR sky130_fd_sc_hd__fill_2
XFILLER_0_47_605 VPWR VGND VPWR VGND sky130_ef_sc_hd__decap_12
XFILLER_0_7_713 VPWR VGND VPWR VGND sky130_ef_sc_hd__decap_12
XFILLER_0_166_1201 VPWR VGND VPWR VGND sky130_ef_sc_hd__decap_12
XFILLER_0_172_643 VPWR VGND VPWR VGND sky130_ef_sc_hd__decap_12
XFILLER_0_7_757 VPWR VGND VPWR VGND sky130_ef_sc_hd__decap_12
XFILLER_0_62_619 VPWR VGND VPWR VGND sky130_ef_sc_hd__decap_12
XFILLER_0_6_245 VGND VGND VPWR VPWR sky130_fd_sc_hd__decap_6
XFILLER_0_104_209 VPWR VGND VPWR VGND sky130_ef_sc_hd__decap_12
XFILLER_0_113_721 VGND VGND VPWR VPWR sky130_fd_sc_hd__decap_6
XFILLER_0_6_289 VPWR VGND VPWR VGND sky130_ef_sc_hd__decap_12
XFILLER_0_207_1253 VGND VGND VPWR VPWR sky130_fd_sc_hd__fill_1
XFILLER_0_113_765 VPWR VGND VPWR VGND sky130_ef_sc_hd__decap_12
Xoutput210 net210 VGND VGND VPWR VPWR psum_col1_out[21] sky130_fd_sc_hd__clkbuf_4
XFILLER_0_28_1337 VGND VGND VPWR VPWR sky130_fd_sc_hd__fill_1
XFILLER_0_64_3 VPWR VGND VPWR VGND sky130_ef_sc_hd__decap_12
Xoutput221 net221 VGND VGND VPWR VPWR psum_col1_out[31] sky130_fd_sc_hd__clkbuf_4
XFILLER_0_112_253 VPWR VGND VPWR VGND sky130_ef_sc_hd__decap_12
XFILLER_0_226_132 VGND VGND VPWR VPWR sky130_fd_sc_hd__fill_1
XFILLER_0_215_839 VGND VGND VPWR VPWR sky130_fd_sc_hd__fill_1
XFILLER_0_4_83 VGND VGND VPWR VPWR sky130_fd_sc_hd__fill_1
XFILLER_0_173_1249 VGND VGND VPWR VPWR sky130_fd_sc_hd__decap_4
XFILLER_0_210_511 VPWR VGND VPWR VGND sky130_ef_sc_hd__decap_12
XFILLER_0_210_533 VGND VGND VPWR VPWR sky130_fd_sc_hd__decap_6
XFILLER_0_38_605 VPWR VGND VPWR VGND sky130_ef_sc_hd__decap_12
XPHY_714 VGND VGND VPWR VPWR sky130_fd_sc_hd__decap_3
XPHY_703 VGND VGND VPWR VPWR sky130_fd_sc_hd__decap_3
XPHY_736 VGND VGND VPWR VPWR sky130_fd_sc_hd__decap_3
XPHY_725 VGND VGND VPWR VPWR sky130_fd_sc_hd__decap_3
XPHY_769 VGND VGND VPWR VPWR sky130_fd_sc_hd__decap_3
XPHY_758 VGND VGND VPWR VPWR sky130_fd_sc_hd__decap_3
XPHY_747 VGND VGND VPWR VPWR sky130_fd_sc_hd__decap_3
XFILLER_0_0_1317 VGND VGND VPWR VPWR sky130_fd_sc_hd__decap_4
XFILLER_0_61_641 VGND VGND VPWR VPWR sky130_fd_sc_hd__decap_4
XFILLER_0_108_1173 VPWR VGND VPWR VGND sky130_ef_sc_hd__decap_12
XFILLER_0_104_1037 VPWR VGND VPWR VGND sky130_ef_sc_hd__decap_12
XANTENNA_input48_A psum_col0_in[22] VGND VGND VPWR VPWR sky130_fd_sc_hd__diode_2
XFILLER_0_79_1213 VPWR VGND VPWR VGND sky130_ef_sc_hd__decap_12
XFILLER_0_219_1113 VGND VGND VPWR VPWR sky130_fd_sc_hd__decap_6
XFILLER_0_218_699 VGND VGND VPWR VPWR sky130_fd_sc_hd__fill_1
XFILLER_0_79_1279 VPWR VGND VPWR VGND sky130_ef_sc_hd__decap_12
XFILLER_0_219_1157 VPWR VGND VPWR VGND sky130_ef_sc_hd__decap_12
XFILLER_0_221_809 VPWR VGND VPWR VGND sky130_ef_sc_hd__decap_12
XFILLER_0_214_861 VGND VGND VPWR VPWR sky130_fd_sc_hd__decap_6
XFILLER_0_216_41 VPWR VGND VPWR VGND sky130_ef_sc_hd__decap_12
XFILLER_0_216_85 VPWR VGND VPWR VGND sky130_ef_sc_hd__decap_12
XFILLER_0_213_393 VPWR VGND VPWR VGND sky130_ef_sc_hd__decap_12
XFILLER_0_119_1291 VPWR VGND VPWR VGND sky130_ef_sc_hd__decap_12
XTAP_2151 VGND VPWR sky130_fd_sc_hd__tapvpwrvgnd_1
XTAP_2140 VGND VPWR sky130_fd_sc_hd__tapvpwrvgnd_1
XTAP_2162 VGND VPWR sky130_fd_sc_hd__tapvpwrvgnd_1
XFILLER_0_29_605 VPWR VGND VPWR VGND sky130_ef_sc_hd__decap_12
XFILLER_0_152_29 VPWR VGND VPWR VGND sky130_ef_sc_hd__decap_12
XFILLER_0_189_1201 VPWR VGND VPWR VGND sky130_ef_sc_hd__decap_12
XTAP_2195 VGND VPWR sky130_fd_sc_hd__tapvpwrvgnd_1
XTAP_2184 VGND VPWR sky130_fd_sc_hd__tapvpwrvgnd_1
XTAP_2173 VGND VPWR sky130_fd_sc_hd__tapvpwrvgnd_1
XFILLER_0_61_27 VPWR VGND VPWR VGND sky130_ef_sc_hd__decap_12
XTAP_1450 VGND VPWR sky130_fd_sc_hd__tapvpwrvgnd_1
XFILLER_0_189_1267 VPWR VGND VPWR VGND sky130_ef_sc_hd__decap_12
XFILLER_0_96_593 VPWR VGND VPWR VGND sky130_ef_sc_hd__decap_12
XTAP_1461 VGND VPWR sky130_fd_sc_hd__tapvpwrvgnd_1
XTAP_1472 VGND VPWR sky130_fd_sc_hd__tapvpwrvgnd_1
XTAP_1483 VGND VPWR sky130_fd_sc_hd__tapvpwrvgnd_1
XFILLER_0_16_1263 VPWR VGND VPWR VGND sky130_ef_sc_hd__decap_12
XFILLER_0_154_643 VPWR VGND VPWR VGND sky130_ef_sc_hd__decap_12
XTAP_1494 VGND VPWR sky130_fd_sc_hd__tapvpwrvgnd_1
XFILLER_0_44_619 VPWR VGND VPWR VGND sky130_ef_sc_hd__decap_12
XFILLER_0_226_1106 VPWR VGND VPWR VGND sky130_ef_sc_hd__decap_12
XFILLER_0_9_39 VGND VGND VPWR VPWR sky130_fd_sc_hd__decap_8
XFILLER_0_86_1239 VPWR VGND VPWR VGND sky130_ef_sc_hd__decap_12
XFILLER_0_114_529 VGND VGND VPWR VPWR sky130_fd_sc_hd__decap_3
XFILLER_0_4_749 VGND VGND VPWR VPWR sky130_fd_sc_hd__decap_6
XFILLER_0_101_22 VPWR VGND VPWR VGND sky130_ef_sc_hd__decap_12
XFILLER_0_3_237 VPWR VGND VPWR VGND sky130_ef_sc_hd__decap_12
XFILLER_0_177_15 VPWR VGND VPWR VGND sky130_ef_sc_hd__decap_12
XFILLER_0_126_1251 VPWR VGND VPWR VGND sky130_ef_sc_hd__decap_12
XFILLER_0_110_713 VPWR VGND VPWR VGND sky130_ef_sc_hd__decap_12
XFILLER_0_0_911 VPWR VGND VPWR VGND sky130_ef_sc_hd__decap_12
XFILLER_0_126_1295 VPWR VGND VPWR VGND sky130_ef_sc_hd__decap_12
XFILLER_0_110_757 VPWR VGND VPWR VGND sky130_ef_sc_hd__decap_12
XFILLER_0_0_933 VPWR VGND VPWR VGND sky130_ef_sc_hd__decap_12
XFILLER_0_23_1201 VPWR VGND VPWR VGND sky130_ef_sc_hd__decap_12
XFILLER_0_196_1227 VPWR VGND VPWR VGND sky130_ef_sc_hd__decap_12
XFILLER_0_0_977 VGND VGND VPWR VPWR sky130_fd_sc_hd__decap_3
XFILLER_0_20_593 VPWR VGND VPWR VGND sky130_ef_sc_hd__decap_12
XFILLER_0_0_999 VGND VGND VPWR VPWR sky130_fd_sc_hd__decap_8
XFILLER_0_62_1283 VPWR VGND VPWR VGND sky130_ef_sc_hd__decap_12
XFILLER_0_97_1335 VGND VGND VPWR VPWR sky130_fd_sc_hd__decap_8
XFILLER_0_23_1267 VPWR VGND VPWR VGND sky130_ef_sc_hd__decap_12
XFILLER_0_224_625 VPWR VGND VPWR VGND sky130_ef_sc_hd__decap_12
XFILLER_0_223_113 VPWR VGND VPWR VGND sky130_ef_sc_hd__decap_12
XFILLER_0_193_47 VGND VGND VPWR VPWR sky130_fd_sc_hd__fill_1
XFILLER_0_58_1319 VPWR VGND VPWR VGND sky130_ef_sc_hd__decap_12
XFILLER_0_224_669 VPWR VGND VPWR VGND sky130_ef_sc_hd__decap_12
XFILLER_0_126_41 VGND VGND VPWR VPWR sky130_fd_sc_hd__decap_8
XFILLER_0_133_1255 VPWR VGND VPWR VGND sky130_ef_sc_hd__decap_12
XFILLER_0_168_1307 VPWR VGND VPWR VGND sky130_ef_sc_hd__decap_12
XFILLER_0_87_593 VPWR VGND VPWR VGND sky130_ef_sc_hd__decap_12
XFILLER_0_30_1227 VPWR VGND VPWR VGND sky130_ef_sc_hd__decap_12
XFILLER_0_105_529 VPWR VGND VPWR VGND sky130_ef_sc_hd__decap_12
XFILLER_0_43_641 VGND VGND VPWR VPWR sky130_fd_sc_hd__decap_4
XFILLER_0_105_1313 VPWR VGND VPWR VGND sky130_ef_sc_hd__decap_12
XFILLER_0_113_573 VPWR VGND VPWR VGND sky130_ef_sc_hd__decap_12
XFILLER_0_11_593 VPWR VGND VPWR VGND sky130_ef_sc_hd__decap_12
XFILLER_0_41_1323 VPWR VGND VPWR VGND sky130_ef_sc_hd__decap_12
XFILLER_0_220_1261 VPWR VGND VPWR VGND sky130_ef_sc_hd__decap_12
XFILLER_0_211_853 VPWR VGND VPWR VGND sky130_ef_sc_hd__decap_12
XFILLER_0_151_1311 VPWR VGND VPWR VGND sky130_ef_sc_hd__decap_12
XFILLER_0_112_1317 VPWR VGND VPWR VGND sky130_ef_sc_hd__decap_12
XPHY_500 VGND VGND VPWR VPWR sky130_fd_sc_hd__decap_3
XANTENNA_input102_A w00[10] VGND VGND VPWR VPWR sky130_fd_sc_hd__diode_2
XFILLER_0_211_897 VPWR VGND VPWR VGND sky130_ef_sc_hd__decap_12
XPHY_522 VGND VGND VPWR VPWR sky130_fd_sc_hd__decap_3
XPHY_511 VGND VGND VPWR VPWR sky130_fd_sc_hd__decap_3
XFILLER_0_78_593 VPWR VGND VPWR VGND sky130_ef_sc_hd__decap_12
XPHY_533 VGND VGND VPWR VPWR sky130_fd_sc_hd__decap_3
XPHY_544 VGND VGND VPWR VPWR sky130_fd_sc_hd__decap_3
XFILLER_0_108_301 VGND VGND VPWR VPWR sky130_fd_sc_hd__decap_6
XPHY_1110 VGND VGND VPWR VPWR sky130_fd_sc_hd__decap_3
XPHY_1132 VGND VGND VPWR VPWR sky130_fd_sc_hd__decap_3
XPHY_1121 VGND VGND VPWR VPWR sky130_fd_sc_hd__decap_3
XPHY_566 VGND VGND VPWR VPWR sky130_fd_sc_hd__decap_3
XPHY_555 VGND VGND VPWR VPWR sky130_fd_sc_hd__decap_3
XFILLER_0_136_643 VPWR VGND VPWR VGND sky130_ef_sc_hd__decap_12
XPHY_577 VGND VGND VPWR VPWR sky130_fd_sc_hd__decap_3
XFILLER_0_26_619 VPWR VGND VPWR VGND sky130_ef_sc_hd__decap_12
XFILLER_0_4_1261 VPWR VGND VPWR VGND sky130_ef_sc_hd__decap_12
XPHY_1165 VGND VGND VPWR VPWR sky130_fd_sc_hd__decap_3
XPHY_1154 VGND VGND VPWR VPWR sky130_fd_sc_hd__decap_3
XPHY_1143 VGND VGND VPWR VPWR sky130_fd_sc_hd__decap_3
XPHY_599 VGND VGND VPWR VPWR sky130_fd_sc_hd__decap_3
XPHY_588 VGND VGND VPWR VPWR sky130_fd_sc_hd__decap_3
XFILLER_0_108_345 VPWR VGND VPWR VGND sky130_ef_sc_hd__decap_12
XPHY_1187 VGND VGND VPWR VPWR sky130_fd_sc_hd__decap_3
XPHY_1176 VGND VGND VPWR VPWR sky130_fd_sc_hd__decap_3
XPHY_1198 VGND VGND VPWR VPWR sky130_fd_sc_hd__decap_3
XFILLER_0_110_1085 VGND VGND VPWR VPWR sky130_fd_sc_hd__decap_6
XFILLER_0_108_389 VPWR VGND VPWR VGND sky130_ef_sc_hd__decap_12
XFILLER_0_46_1201 VPWR VGND VPWR VGND sky130_ef_sc_hd__decap_12
XFILLER_0_104_573 VPWR VGND VPWR VGND sky130_ef_sc_hd__decap_12
XFILLER_0_0_207 VPWR VGND VPWR VGND sky130_ef_sc_hd__decap_12
XFILLER_0_219_953 VPWR VGND VPWR VGND sky130_ef_sc_hd__decap_12
XFILLER_0_56_49 VGND VGND VPWR VPWR sky130_fd_sc_hd__fill_1
XFILLER_0_221_617 VPWR VGND VPWR VGND sky130_ef_sc_hd__decap_12
XFILLER_0_72_15 VPWR VGND VPWR VGND sky130_ef_sc_hd__decap_12
XFILLER_0_163_39 VGND VGND VPWR VPWR sky130_fd_sc_hd__decap_8
XFILLER_0_53_1249 VGND VGND VPWR VPWR sky130_fd_sc_hd__decap_4
XFILLER_0_69_593 VPWR VGND VPWR VGND sky130_ef_sc_hd__decap_12
XTAP_1280 VGND VPWR sky130_fd_sc_hd__tapvpwrvgnd_1
XTAP_1291 VGND VPWR sky130_fd_sc_hd__tapvpwrvgnd_1
XFILLER_0_112_10 VPWR VGND VPWR VGND sky130_ef_sc_hd__decap_12
XFILLER_0_4_513 VPWR VGND VPWR VGND sky130_ef_sc_hd__decap_12
XFILLER_0_25_641 VGND VGND VPWR VPWR sky130_fd_sc_hd__decap_4
XFILLER_0_112_65 VPWR VGND VPWR VGND sky130_ef_sc_hd__decap_12
XFILLER_0_163_1237 VPWR VGND VPWR VGND sky130_ef_sc_hd__decap_12
XFILLER_0_4_557 VPWR VGND VPWR VGND sky130_ef_sc_hd__decap_12
XFILLER_0_114_337 VPWR VGND VPWR VGND sky130_ef_sc_hd__decap_12
XFILLER_0_204_1201 VPWR VGND VPWR VGND sky130_ef_sc_hd__decap_12
XFILLER_0_40_655 VGND VGND VPWR VPWR sky130_fd_sc_hd__decap_4
XFILLER_0_0_763 VGND VGND VPWR VPWR sky130_fd_sc_hd__decap_8
XFILLER_0_110_587 VGND VGND VPWR VPWR sky130_fd_sc_hd__fill_1
XFILLER_0_0_785 VGND VGND VPWR VPWR sky130_fd_sc_hd__decap_8
XFILLER_0_225_945 VGND VGND VPWR VPWR sky130_fd_sc_hd__decap_6
XFILLER_0_224_433 VPWR VGND VPWR VGND sky130_ef_sc_hd__decap_12
XANTENNA_u_pe10_weight_in[9] net148 VGND VGND VPWR VPWR sky130_fd_sc_hd__diode_2
XFILLER_0_225_989 VPWR VGND VPWR VGND sky130_ef_sc_hd__decap_12
XTAP_2909 VGND VPWR sky130_fd_sc_hd__tapvpwrvgnd_1
XFILLER_0_224_477 VPWR VGND VPWR VGND sky130_ef_sc_hd__decap_12
XFILLER_0_211_105 VGND VGND VPWR VPWR sky130_fd_sc_hd__decap_6
XFILLER_0_27_3 VPWR VGND VPWR VGND sky130_ef_sc_hd__decap_12
XFILLER_0_211_149 VPWR VGND VPWR VGND sky130_ef_sc_hd__decap_12
XFILLER_0_69_1201 VPWR VGND VPWR VGND sky130_ef_sc_hd__decap_12
XFILLER_0_118_643 VPWR VGND VPWR VGND sky130_ef_sc_hd__decap_12
XFILLER_0_106_805 VGND VGND VPWR VPWR sky130_fd_sc_hd__decap_6
XFILLER_0_106_849 VPWR VGND VPWR VGND sky130_ef_sc_hd__decap_12
XFILLER_0_69_1267 VPWR VGND VPWR VGND sky130_ef_sc_hd__decap_12
XFILLER_0_105_337 VPWR VGND VPWR VGND sky130_ef_sc_hd__decap_12
XFILLER_0_31_655 VGND VGND VPWR VPWR sky130_fd_sc_hd__fill_2
XFILLER_0_219_205 VPWR VGND VPWR VGND sky130_ef_sc_hd__decap_12
XFILLER_0_105_1121 VPWR VGND VPWR VGND sky130_ef_sc_hd__decap_12
XFILLER_0_114_893 VGND VGND VPWR VPWR sky130_fd_sc_hd__decap_3
XFILLER_0_219_249 VPWR VGND VPWR VGND sky130_ef_sc_hd__decap_12
XFILLER_0_179_1255 VPWR VGND VPWR VGND sky130_ef_sc_hd__decap_12
XFILLER_0_220_1091 VGND VGND VPWR VPWR sky130_fd_sc_hd__fill_1
XFILLER_0_216_923 VGND VGND VPWR VPWR sky130_fd_sc_hd__fill_1
XFILLER_0_76_1227 VPWR VGND VPWR VGND sky130_ef_sc_hd__decap_12
XFILLER_0_216_1105 VPWR VGND VPWR VGND sky130_ef_sc_hd__decap_12
XFILLER_0_203_617 VPWR VGND VPWR VGND sky130_ef_sc_hd__decap_12
XFILLER_0_216_1149 VPWR VGND VPWR VGND sky130_ef_sc_hd__decap_12
XFILLER_0_98_655 VGND VGND VPWR VPWR sky130_fd_sc_hd__decap_4
XFILLER_0_116_1283 VPWR VGND VPWR VGND sky130_ef_sc_hd__decap_12
XFILLER_0_42_29 VPWR VGND VPWR VGND sky130_ef_sc_hd__decap_12
XFILLER_0_210_193 VGND VGND VPWR VPWR sky130_fd_sc_hd__decap_3
XFILLER_0_112_1147 VGND VGND VPWR VPWR sky130_fd_sc_hd__fill_1
XPHY_341 VGND VGND VPWR VPWR sky130_fd_sc_hd__decap_3
XPHY_352 VGND VGND VPWR VPWR sky130_fd_sc_hd__decap_3
XPHY_330 VGND VGND VPWR VPWR sky130_fd_sc_hd__decap_3
XFILLER_0_109_665 VGND VGND VPWR VPWR sky130_fd_sc_hd__decap_6
XPHY_385 VGND VGND VPWR VPWR sky130_fd_sc_hd__decap_3
XFILLER_0_13_1255 VPWR VGND VPWR VGND sky130_ef_sc_hd__decap_12
XPHY_363 VGND VGND VPWR VPWR sky130_fd_sc_hd__decap_3
XPHY_374 VGND VGND VPWR VPWR sky130_fd_sc_hd__decap_3
XFILLER_0_87_1323 VPWR VGND VPWR VGND sky130_ef_sc_hd__decap_12
XPHY_396 VGND VGND VPWR VPWR sky130_fd_sc_hd__decap_3
XFILLER_0_4_1091 VGND VGND VPWR VPWR sky130_fd_sc_hd__fill_1
XFILLER_0_48_1307 VPWR VGND VPWR VGND sky130_ef_sc_hd__decap_12
XFILLER_0_108_153 VPWR VGND VPWR VGND sky130_ef_sc_hd__decap_12
XFILLER_0_206_9 VGND VGND VPWR VPWR sky130_fd_sc_hd__fill_2
XFILLER_0_108_197 VPWR VGND VPWR VGND sky130_ef_sc_hd__decap_12
XFILLER_0_1_505 VPWR VGND VPWR VGND sky130_ef_sc_hd__decap_12
XFILLER_0_6_29 VPWR VGND VPWR VGND sky130_ef_sc_hd__decap_12
XFILLER_0_22_655 VGND VGND VPWR VPWR sky130_fd_sc_hd__decap_4
XFILLER_0_111_329 VGND VGND VPWR VPWR sky130_fd_sc_hd__decap_6
XFILLER_0_197_1311 VPWR VGND VPWR VGND sky130_ef_sc_hd__decap_12
XFILLER_0_162_1281 VGND VGND VPWR VPWR sky130_fd_sc_hd__fill_1
XFILLER_0_67_15 VPWR VGND VPWR VGND sky130_ef_sc_hd__decap_12
XFILLER_0_219_783 VGND VGND VPWR VPWR sky130_fd_sc_hd__fill_1
XFILLER_0_158_1339 VGND VGND VPWR VPWR sky130_fd_sc_hd__decap_4
XANTENNA_u_pe11_rst_n net98 VGND VGND VPWR VPWR sky130_fd_sc_hd__diode_2
XFILLER_0_174_27 VGND VGND VPWR VPWR sky130_fd_sc_hd__fill_1
XFILLER_0_222_937 VPWR VGND VPWR VGND sky130_ef_sc_hd__decap_12
XFILLER_0_83_47 VGND VGND VPWR VPWR sky130_fd_sc_hd__decap_3
XFILLER_0_174_49 VGND VGND VPWR VPWR sky130_fd_sc_hd__fill_1
XFILLER_0_221_447 VGND VGND VPWR VPWR sky130_fd_sc_hd__fill_1
XFILLER_0_16_41 VGND VGND VPWR VPWR sky130_fd_sc_hd__decap_8
XFILLER_0_190_15 VPWR VGND VPWR VGND sky130_ef_sc_hd__decap_12
XFILLER_0_9_605 VPWR VGND VPWR VGND sky130_ef_sc_hd__decap_12
XFILLER_0_130_1225 VGND VGND VPWR VPWR sky130_fd_sc_hd__fill_1
XFILLER_0_31_1311 VPWR VGND VPWR VGND sky130_ef_sc_hd__decap_12
XFILLER_0_199_13 VPWR VGND VPWR VGND sky130_ef_sc_hd__decap_12
XFILLER_0_5_833 VGND VGND VPWR VPWR sky130_fd_sc_hd__decap_6
XFILLER_0_206_1307 VPWR VGND VPWR VGND sky130_ef_sc_hd__decap_12
XFILLER_0_4_321 VPWR VGND VPWR VGND sky130_ef_sc_hd__decap_12
XFILLER_0_130_605 VPWR VGND VPWR VGND sky130_ef_sc_hd__decap_12
XFILLER_0_4_365 VPWR VGND VPWR VGND sky130_ef_sc_hd__decap_12
XFILLER_0_5_877 VPWR VGND VPWR VGND sky130_ef_sc_hd__decap_12
XFILLER_0_141_1343 VGND VGND VPWR VPWR sky130_fd_sc_hd__fill_1
XFILLER_0_111_841 VPWR VGND VPWR VGND sky130_ef_sc_hd__decap_12
XFILLER_0_217_709 VPWR VGND VPWR VGND sky130_ef_sc_hd__decap_12
XFILLER_0_99_1249 VGND VGND VPWR VPWR sky130_fd_sc_hd__decap_4
XFILLER_0_225_753 VPWR VGND VPWR VGND sky130_ef_sc_hd__decap_12
XFILLER_0_225_797 VPWR VGND VPWR VGND sky130_ef_sc_hd__decap_12
XFILLER_0_197_605 VPWR VGND VPWR VGND sky130_ef_sc_hd__decap_12
XTAP_2706 VGND VPWR sky130_fd_sc_hd__tapvpwrvgnd_1
XTAP_2728 VGND VPWR sky130_fd_sc_hd__tapvpwrvgnd_1
XTAP_2717 VGND VPWR sky130_fd_sc_hd__tapvpwrvgnd_1
XTAP_2739 VGND VPWR sky130_fd_sc_hd__tapvpwrvgnd_1
XFILLER_0_212_469 VGND VGND VPWR VPWR sky130_fd_sc_hd__decap_6
XFILLER_0_95_647 VPWR VGND VPWR VGND sky130_ef_sc_hd__decap_12
XFILLER_0_211_1057 VGND VGND VPWR VPWR sky130_fd_sc_hd__decap_6
XFILLER_0_106_613 VPWR VGND VPWR VGND sky130_ef_sc_hd__decap_12
XFILLER_0_1_1231 VGND VGND VPWR VPWR sky130_fd_sc_hd__fill_1
XFILLER_0_106_657 VPWR VGND VPWR VGND sky130_ef_sc_hd__decap_12
XFILLER_0_7_181 VPWR VGND VPWR VGND sky130_ef_sc_hd__decap_12
XFILLER_0_121_605 VPWR VGND VPWR VGND sky130_ef_sc_hd__decap_12
XFILLER_0_105_167 VGND VGND VPWR VPWR sky130_fd_sc_hd__fill_1
XFILLER_0_43_1237 VPWR VGND VPWR VGND sky130_ef_sc_hd__decap_12
XFILLER_0_82_1275 VGND VGND VPWR VPWR sky130_fd_sc_hd__decap_6
XFILLER_0_222_1197 VGND VGND VPWR VPWR sky130_fd_sc_hd__decap_6
Xinput110 w00[3] VGND VGND VPWR VPWR net110 sky130_fd_sc_hd__buf_1
Xinput154 w11[14] VGND VGND VPWR VPWR net154 sky130_fd_sc_hd__clkbuf_8
Xinput143 w10[4] VGND VGND VPWR VPWR net143 sky130_fd_sc_hd__clkbuf_4
Xinput121 w01[13] VGND VGND VPWR VPWR net121 sky130_fd_sc_hd__clkbuf_4
Xinput132 w01[9] VGND VGND VPWR VPWR net132 sky130_fd_sc_hd__buf_4
XANTENNA_input30_A act_row1_in[7] VGND VGND VPWR VPWR sky130_fd_sc_hd__diode_2
XFILLER_0_188_605 VPWR VGND VPWR VGND sky130_ef_sc_hd__decap_12
XFILLER_0_192_1263 VPWR VGND VPWR VGND sky130_ef_sc_hd__decap_12
XFILLER_0_153_1225 VPWR VGND VPWR VGND sky130_ef_sc_hd__decap_12
XFILLER_0_53_39 VGND VGND VPWR VPWR sky130_fd_sc_hd__decap_8
XFILLER_0_212_981 VPWR VGND VPWR VGND sky130_ef_sc_hd__decap_12
XFILLER_0_224_41 VPWR VGND VPWR VGND sky130_ef_sc_hd__decap_12
XFILLER_0_224_85 VPWR VGND VPWR VGND sky130_ef_sc_hd__decap_12
XPHY_160 VGND VGND VPWR VPWR sky130_fd_sc_hd__decap_3
XFILLER_0_2_1017 VPWR VGND VPWR VGND sky130_ef_sc_hd__decap_12
XFILLER_0_6_1197 VGND VGND VPWR VPWR sky130_fd_sc_hd__decap_6
XFILLER_0_160_29 VPWR VGND VPWR VGND sky130_ef_sc_hd__decap_12
XPHY_193 VGND VGND VPWR VPWR sky130_fd_sc_hd__decap_3
XPHY_171 VGND VGND VPWR VPWR sky130_fd_sc_hd__decap_3
XPHY_182 VGND VGND VPWR VPWR sky130_fd_sc_hd__decap_3
XFILLER_0_109_473 VPWR VGND VPWR VGND sky130_ef_sc_hd__decap_12
XFILLER_0_164_1343 VGND VGND VPWR VPWR sky130_fd_sc_hd__fill_1
XFILLER_0_169_27 VPWR VGND VPWR VGND sky130_ef_sc_hd__decap_12
XFILLER_0_2_825 VPWR VGND VPWR VGND sky130_ef_sc_hd__decap_12
XFILLER_0_2_869 VPWR VGND VPWR VGND sky130_ef_sc_hd__decap_12
XFILLER_0_1_335 VGND VGND VPWR VPWR sky130_fd_sc_hd__fill_1
XFILLER_0_111_137 VPWR VGND VPWR VGND sky130_ef_sc_hd__decap_12
XFILLER_0_201_1237 VPWR VGND VPWR VGND sky130_ef_sc_hd__decap_12
XFILLER_0_185_37 VGND VGND VPWR VPWR sky130_fd_sc_hd__decap_8
XFILLER_0_222_701 VPWR VGND VPWR VGND sky130_ef_sc_hd__decap_12
XFILLER_0_179_605 VPWR VGND VPWR VGND sky130_ef_sc_hd__decap_12
XFILLER_0_59_1255 VPWR VGND VPWR VGND sky130_ef_sc_hd__decap_12
XFILLER_0_171_1303 VGND VGND VPWR VPWR sky130_fd_sc_hd__decap_6
XFILLER_0_210_929 VGND VGND VPWR VPWR sky130_fd_sc_hd__decap_8
XFILLER_0_194_619 VPWR VGND VPWR VGND sky130_ef_sc_hd__decap_12
XFILLER_0_77_647 VGND VGND VPWR VPWR sky130_fd_sc_hd__decap_8
XFILLER_0_134_41 VGND VGND VPWR VPWR sky130_fd_sc_hd__decap_8
XFILLER_0_92_617 VGND VGND VPWR VPWR sky130_fd_sc_hd__fill_1
XFILLER_0_210_1090 VGND VGND VPWR VPWR sky130_fd_sc_hd__fill_2
XFILLER_0_5_641 VPWR VGND VPWR VGND sky130_ef_sc_hd__decap_12
XFILLER_0_103_605 VPWR VGND VPWR VGND sky130_ef_sc_hd__decap_12
XFILLER_0_170_593 VPWR VGND VPWR VGND sky130_ef_sc_hd__decap_12
XFILLER_0_5_685 VPWR VGND VPWR VGND sky130_ef_sc_hd__decap_12
XFILLER_0_4_195 VGND VGND VPWR VPWR sky130_fd_sc_hd__fill_1
XFILLER_0_111_671 VGND VGND VPWR VPWR sky130_fd_sc_hd__fill_1
XFILLER_0_217_517 VPWR VGND VPWR VGND sky130_ef_sc_hd__decap_12
XFILLER_0_176_1225 VGND VGND VPWR VPWR sky130_fd_sc_hd__fill_1
XFILLER_0_42_1281 VGND VGND VPWR VPWR sky130_fd_sc_hd__fill_1
XFILLER_0_77_1311 VPWR VGND VPWR VGND sky130_ef_sc_hd__decap_12
XFILLER_0_225_561 VPWR VGND VPWR VGND sky130_ef_sc_hd__decap_12
XFILLER_0_217_1233 VPWR VGND VPWR VGND sky130_ef_sc_hd__decap_12
XFILLER_0_38_1339 VGND VGND VPWR VPWR sky130_fd_sc_hd__decap_4
XTAP_2503 VGND VPWR sky130_fd_sc_hd__tapvpwrvgnd_1
XTAP_2514 VGND VPWR sky130_fd_sc_hd__tapvpwrvgnd_1
XTAP_2536 VGND VPWR sky130_fd_sc_hd__tapvpwrvgnd_1
XFILLER_0_212_233 VPWR VGND VPWR VGND sky130_ef_sc_hd__decap_12
XTAP_2525 VGND VPWR sky130_fd_sc_hd__tapvpwrvgnd_1
XFILLER_0_213_1119 VGND VGND VPWR VPWR sky130_fd_sc_hd__fill_1
XTAP_2558 VGND VPWR sky130_fd_sc_hd__tapvpwrvgnd_1
XTAP_2547 VGND VPWR sky130_fd_sc_hd__tapvpwrvgnd_1
XFILLER_0_212_277 VPWR VGND VPWR VGND sky130_ef_sc_hd__decap_12
XTAP_2569 VGND VPWR sky130_fd_sc_hd__tapvpwrvgnd_1
XTAP_1824 VGND VPWR sky130_fd_sc_hd__tapvpwrvgnd_1
XTAP_1802 VGND VPWR sky130_fd_sc_hd__tapvpwrvgnd_1
XTAP_1813 VGND VPWR sky130_fd_sc_hd__tapvpwrvgnd_1
XFILLER_0_113_1231 VGND VGND VPWR VPWR sky130_fd_sc_hd__fill_1
XTAP_1835 VGND VPWR sky130_fd_sc_hd__tapvpwrvgnd_1
XTAP_1857 VGND VPWR sky130_fd_sc_hd__tapvpwrvgnd_1
XFILLER_0_83_617 VPWR VGND VPWR VGND sky130_ef_sc_hd__decap_12
XTAP_1846 VGND VPWR sky130_fd_sc_hd__tapvpwrvgnd_1
XFILLER_0_193_641 VGND VGND VPWR VPWR sky130_fd_sc_hd__decap_4
XTAP_1879 VGND VPWR sky130_fd_sc_hd__tapvpwrvgnd_1
XTAP_1868 VGND VPWR sky130_fd_sc_hd__tapvpwrvgnd_1
XFILLER_0_3_1337 VGND VGND VPWR VPWR sky130_fd_sc_hd__decap_6
XFILLER_0_187_1343 VGND VGND VPWR VPWR sky130_fd_sc_hd__fill_1
XFILLER_0_10_1225 VGND VGND VPWR VPWR sky130_fd_sc_hd__fill_1
XFILLER_0_107_933 VPWR VGND VPWR VGND sky130_ef_sc_hd__decap_12
XFILLER_0_106_421 VPWR VGND VPWR VGND sky130_ef_sc_hd__decap_12
XFILLER_0_107_977 VPWR VGND VPWR VGND sky130_ef_sc_hd__decap_12
XFILLER_0_84_1337 VGND VGND VPWR VPWR sky130_fd_sc_hd__fill_1
XANTENNA_input78_A psum_col1_in[20] VGND VGND VPWR VPWR sky130_fd_sc_hd__diode_2
XFILLER_0_161_593 VPWR VGND VPWR VGND sky130_ef_sc_hd__decap_12
XFILLER_0_224_1259 VGND VGND VPWR VPWR sky130_fd_sc_hd__fill_1
XFILLER_0_107_1057 VGND VGND VPWR VPWR sky130_fd_sc_hd__decap_6
XFILLER_0_120_1213 VPWR VGND VPWR VGND sky130_ef_sc_hd__decap_12
XFILLER_0_21_1343 VGND VGND VPWR VPWR sky130_fd_sc_hd__fill_1
XFILLER_0_200_1281 VGND VGND VPWR VPWR sky130_fd_sc_hd__fill_1
XFILLER_0_155_1309 VGND VGND VPWR VPWR sky130_fd_sc_hd__fill_1
XFILLER_0_64_27 VGND VGND VPWR VPWR sky130_fd_sc_hd__fill_1
XFILLER_0_64_49 VGND VGND VPWR VPWR sky130_fd_sc_hd__fill_1
XFILLER_0_176_619 VPWR VGND VPWR VGND sky130_ef_sc_hd__decap_12
XFILLER_0_59_647 VGND VGND VPWR VPWR sky130_fd_sc_hd__decap_8
XFILLER_0_154_6 VGND VGND VPWR VPWR sky130_fd_sc_hd__fill_2
XFILLER_0_74_617 VGND VGND VPWR VPWR sky130_fd_sc_hd__fill_1
XFILLER_0_89_1237 VPWR VGND VPWR VGND sky130_ef_sc_hd__decap_12
XFILLER_0_109_281 VPWR VGND VPWR VGND sky130_ef_sc_hd__decap_12
XFILLER_0_202_3 VPWR VGND VPWR VGND sky130_ef_sc_hd__decap_12
XFILLER_0_152_593 VPWR VGND VPWR VGND sky130_ef_sc_hd__decap_12
XFILLER_0_112_413 VGND VGND VPWR VPWR sky130_fd_sc_hd__decap_6
XFILLER_0_196_25 VGND VGND VPWR VPWR sky130_fd_sc_hd__decap_3
XFILLER_0_112_457 VPWR VGND VPWR VGND sky130_ef_sc_hd__decap_12
XFILLER_0_199_1225 VPWR VGND VPWR VGND sky130_ef_sc_hd__decap_12
XFILLER_0_100_619 VPWR VGND VPWR VGND sky130_ef_sc_hd__decap_12
XFILLER_0_2_699 VGND VGND VPWR VPWR sky130_fd_sc_hd__fill_1
XFILLER_0_226_314 VGND VGND VPWR VPWR sky130_fd_sc_hd__fill_2
XFILLER_0_226_358 VGND VGND VPWR VPWR sky130_fd_sc_hd__decap_6
XFILLER_0_175_1291 VPWR VGND VPWR VGND sky130_ef_sc_hd__decap_12
XFILLER_0_222_531 VGND VGND VPWR VPWR sky130_fd_sc_hd__fill_1
XFILLER_0_136_1275 VGND VGND VPWR VPWR sky130_fd_sc_hd__decap_6
XFILLER_0_212_1141 VGND VGND VPWR VPWR sky130_fd_sc_hd__decap_6
XPHY_918 VGND VGND VPWR VPWR sky130_fd_sc_hd__decap_3
XPHY_907 VGND VGND VPWR VPWR sky130_fd_sc_hd__decap_3
XFILLER_0_33_1225 VPWR VGND VPWR VGND sky130_ef_sc_hd__decap_12
XFILLER_0_72_1263 VPWR VGND VPWR VGND sky130_ef_sc_hd__decap_12
XFILLER_0_175_641 VGND VGND VPWR VPWR sky130_fd_sc_hd__decap_4
XPHY_929 VGND VGND VPWR VPWR sky130_fd_sc_hd__decap_3
XFILLER_0_65_617 VPWR VGND VPWR VGND sky130_ef_sc_hd__decap_12
XFILLER_0_212_1185 VPWR VGND VPWR VGND sky130_ef_sc_hd__decap_12
XFILLER_0_190_655 VGND VGND VPWR VPWR sky130_fd_sc_hd__decap_4
XFILLER_0_6_961 VPWR VGND VPWR VGND sky130_ef_sc_hd__decap_12
XFILLER_0_182_1251 VPWR VGND VPWR VGND sky130_ef_sc_hd__decap_12
XFILLER_0_143_1213 VPWR VGND VPWR VGND sky130_ef_sc_hd__decap_12
XFILLER_0_143_593 VPWR VGND VPWR VGND sky130_ef_sc_hd__decap_12
XFILLER_0_104_925 VPWR VGND VPWR VGND sky130_ef_sc_hd__decap_12
XFILLER_0_182_1295 VPWR VGND VPWR VGND sky130_ef_sc_hd__decap_12
XFILLER_0_143_1279 VPWR VGND VPWR VGND sky130_ef_sc_hd__decap_12
XFILLER_0_44_1343 VGND VGND VPWR VPWR sky130_fd_sc_hd__fill_1
XFILLER_0_223_1281 VGND VGND VPWR VPWR sky130_fd_sc_hd__decap_6
XFILLER_0_218_837 VPWR VGND VPWR VGND sky130_ef_sc_hd__decap_12
XANTENNA_input132_A w01[9] VGND VGND VPWR VPWR sky130_fd_sc_hd__diode_2
XFILLER_0_213_553 VGND VGND VPWR VPWR sky130_fd_sc_hd__decap_6
XFILLER_0_225_391 VGND VGND VPWR VPWR sky130_fd_sc_hd__fill_1
XTAP_2311 VGND VPWR sky130_fd_sc_hd__tapvpwrvgnd_1
XFILLER_0_154_1331 VGND VGND VPWR VPWR sky130_fd_sc_hd__decap_6
XTAP_2300 VGND VPWR sky130_fd_sc_hd__tapvpwrvgnd_1
XFILLER_0_217_1063 VGND VGND VPWR VPWR sky130_fd_sc_hd__fill_1
XTAP_2344 VGND VPWR sky130_fd_sc_hd__tapvpwrvgnd_1
XTAP_2333 VGND VPWR sky130_fd_sc_hd__tapvpwrvgnd_1
XTAP_2322 VGND VPWR sky130_fd_sc_hd__tapvpwrvgnd_1
XFILLER_0_158_619 VPWR VGND VPWR VGND sky130_ef_sc_hd__decap_12
XFILLER_0_213_597 VPWR VGND VPWR VGND sky130_ef_sc_hd__decap_12
XTAP_2355 VGND VPWR sky130_fd_sc_hd__tapvpwrvgnd_1
XFILLER_0_150_1239 VPWR VGND VPWR VGND sky130_ef_sc_hd__decap_12
XTAP_2366 VGND VPWR sky130_fd_sc_hd__tapvpwrvgnd_1
XTAP_1621 VGND VPWR sky130_fd_sc_hd__tapvpwrvgnd_1
XTAP_1610 VGND VPWR sky130_fd_sc_hd__tapvpwrvgnd_1
XFILLER_0_51_1303 VGND VGND VPWR VPWR sky130_fd_sc_hd__decap_6
XTAP_1632 VGND VPWR sky130_fd_sc_hd__tapvpwrvgnd_1
XTAP_2377 VGND VPWR sky130_fd_sc_hd__tapvpwrvgnd_1
XTAP_2399 VGND VPWR sky130_fd_sc_hd__tapvpwrvgnd_1
XTAP_2388 VGND VPWR sky130_fd_sc_hd__tapvpwrvgnd_1
XFILLER_0_56_617 VGND VGND VPWR VPWR sky130_fd_sc_hd__fill_1
XTAP_1654 VGND VPWR sky130_fd_sc_hd__tapvpwrvgnd_1
XFILLER_0_3_1101 VPWR VGND VPWR VGND sky130_ef_sc_hd__decap_12
XTAP_1643 VGND VPWR sky130_fd_sc_hd__tapvpwrvgnd_1
XTAP_1665 VGND VPWR sky130_fd_sc_hd__tapvpwrvgnd_1
XTAP_1676 VGND VPWR sky130_fd_sc_hd__tapvpwrvgnd_1
XFILLER_0_50_29 VPWR VGND VPWR VGND sky130_ef_sc_hd__decap_12
XTAP_1698 VGND VPWR sky130_fd_sc_hd__tapvpwrvgnd_1
XFILLER_0_3_1145 VPWR VGND VPWR VGND sky130_ef_sc_hd__decap_12
XTAP_1687 VGND VPWR sky130_fd_sc_hd__tapvpwrvgnd_1
XFILLER_0_181_655 VGND VGND VPWR VPWR sky130_fd_sc_hd__fill_2
XFILLER_0_3_1189 VPWR VGND VPWR VGND sky130_ef_sc_hd__decap_12
XFILLER_0_88_1281 VGND VGND VPWR VPWR sky130_fd_sc_hd__fill_1
XFILLER_0_107_741 VPWR VGND VPWR VGND sky130_ef_sc_hd__decap_12
XFILLER_0_109_1119 VGND VGND VPWR VPWR sky130_fd_sc_hd__fill_1
XFILLER_0_134_593 VPWR VGND VPWR VGND sky130_ef_sc_hd__decap_12
XFILLER_0_107_785 VPWR VGND VPWR VGND sky130_ef_sc_hd__decap_12
XFILLER_0_106_251 VGND VGND VPWR VPWR sky130_fd_sc_hd__fill_1
XFILLER_0_161_1335 VGND VGND VPWR VPWR sky130_fd_sc_hd__fill_1
XFILLER_0_122_1319 VPWR VGND VPWR VGND sky130_ef_sc_hd__decap_12
XFILLER_0_110_917 VGND VGND VPWR VPWR sky130_fd_sc_hd__decap_6
XFILLER_0_75_15 VPWR VGND VPWR VGND sky130_ef_sc_hd__decap_12
XFILLER_0_159_1253 VGND VGND VPWR VPWR sky130_fd_sc_hd__fill_1
XFILLER_0_223_317 VPWR VGND VPWR VGND sky130_ef_sc_hd__decap_12
XFILLER_0_56_1225 VGND VGND VPWR VPWR sky130_fd_sc_hd__fill_1
XFILLER_0_182_49 VGND VGND VPWR VPWR sky130_fd_sc_hd__fill_1
XFILLER_0_152_3 VPWR VGND VPWR VGND sky130_ef_sc_hd__decap_12
XFILLER_0_24_41 VGND VGND VPWR VPWR sky130_fd_sc_hd__decap_8
XFILLER_0_157_641 VGND VGND VPWR VPWR sky130_fd_sc_hd__decap_4
XFILLER_0_47_617 VPWR VGND VPWR VGND sky130_ef_sc_hd__decap_12
XFILLER_0_7_725 VGND VGND VPWR VPWR sky130_fd_sc_hd__decap_3
XFILLER_0_166_1213 VPWR VGND VPWR VGND sky130_ef_sc_hd__decap_12
XFILLER_0_172_655 VGND VGND VPWR VPWR sky130_fd_sc_hd__decap_4
XFILLER_0_7_769 VPWR VGND VPWR VGND sky130_ef_sc_hd__decap_12
XFILLER_0_70_631 VPWR VGND VPWR VGND sky130_ef_sc_hd__decap_12
XFILLER_0_67_1343 VGND VGND VPWR VPWR sky130_fd_sc_hd__fill_1
XFILLER_0_125_593 VPWR VGND VPWR VGND sky130_ef_sc_hd__decap_12
XFILLER_0_3_953 VPWR VGND VPWR VGND sky130_ef_sc_hd__decap_12
Xoutput200 net200 VGND VGND VPWR VPWR psum_col1_out[12] sky130_fd_sc_hd__clkbuf_4
XFILLER_0_112_221 VPWR VGND VPWR VGND sky130_ef_sc_hd__decap_12
XFILLER_0_113_777 VGND VGND VPWR VPWR sky130_fd_sc_hd__decap_6
Xoutput222 net222 VGND VGND VPWR VPWR psum_col1_out[3] sky130_fd_sc_hd__clkbuf_4
Xoutput211 net211 VGND VGND VPWR VPWR psum_col1_out[22] sky130_fd_sc_hd__clkbuf_4
XFILLER_0_112_265 VPWR VGND VPWR VGND sky130_ef_sc_hd__decap_12
XFILLER_0_57_3 VPWR VGND VPWR VGND sky130_ef_sc_hd__decap_12
XFILLER_0_138_1337 VGND VGND VPWR VPWR sky130_fd_sc_hd__fill_1
XFILLER_0_214_1203 VGND VGND VPWR VPWR sky130_fd_sc_hd__fill_1
XFILLER_0_223_895 VGND VGND VPWR VPWR sky130_fd_sc_hd__fill_1
XFILLER_0_35_1309 VGND VGND VPWR VPWR sky130_fd_sc_hd__fill_1
XFILLER_0_210_523 VGND VGND VPWR VPWR sky130_fd_sc_hd__fill_1
XFILLER_0_210_556 VGND VGND VPWR VPWR sky130_fd_sc_hd__decap_4
XPHY_726 VGND VGND VPWR VPWR sky130_fd_sc_hd__decap_3
XPHY_715 VGND VGND VPWR VPWR sky130_fd_sc_hd__decap_3
XFILLER_0_38_617 VGND VGND VPWR VPWR sky130_fd_sc_hd__fill_1
XPHY_704 VGND VGND VPWR VPWR sky130_fd_sc_hd__decap_3
XFILLER_0_210_589 VPWR VGND VPWR VGND sky130_ef_sc_hd__decap_12
XPHY_748 VGND VGND VPWR VPWR sky130_fd_sc_hd__decap_3
XPHY_737 VGND VGND VPWR VPWR sky130_fd_sc_hd__decap_3
XPHY_759 VGND VGND VPWR VPWR sky130_fd_sc_hd__decap_3
XFILLER_0_0_1307 VGND VGND VPWR VPWR sky130_fd_sc_hd__decap_8
XFILLER_0_163_655 VGND VGND VPWR VPWR sky130_fd_sc_hd__fill_2
XFILLER_0_0_1329 VGND VGND VPWR VPWR sky130_fd_sc_hd__decap_3
XFILLER_0_108_1141 VGND VGND VPWR VPWR sky130_fd_sc_hd__decap_6
XFILLER_0_116_593 VPWR VGND VPWR VGND sky130_ef_sc_hd__decap_12
XFILLER_0_104_1005 VGND VGND VPWR VPWR sky130_fd_sc_hd__decap_3
XFILLER_0_218_601 VPWR VGND VPWR VGND sky130_ef_sc_hd__decap_12
XFILLER_0_108_1185 VPWR VGND VPWR VGND sky130_ef_sc_hd__decap_12
XFILLER_0_218_645 VPWR VGND VPWR VGND sky130_ef_sc_hd__decap_12
XFILLER_0_217_111 VGND VGND VPWR VPWR sky130_fd_sc_hd__fill_1
XFILLER_0_104_1049 VPWR VGND VPWR VGND sky130_ef_sc_hd__decap_12
XFILLER_0_79_1225 VPWR VGND VPWR VGND sky130_ef_sc_hd__decap_12
XFILLER_0_219_1169 VGND VGND VPWR VPWR sky130_fd_sc_hd__decap_6
XFILLER_0_220_309 VPWR VGND VPWR VGND sky130_ef_sc_hd__decap_12
XFILLER_0_216_53 VPWR VGND VPWR VGND sky130_ef_sc_hd__decap_12
XFILLER_0_213_361 VPWR VGND VPWR VGND sky130_ef_sc_hd__decap_12
XFILLER_0_216_97 VPWR VGND VPWR VGND sky130_ef_sc_hd__decap_12
XTAP_2152 VGND VPWR sky130_fd_sc_hd__tapvpwrvgnd_1
XTAP_2141 VGND VPWR sky130_fd_sc_hd__tapvpwrvgnd_1
XTAP_2130 VGND VPWR sky130_fd_sc_hd__tapvpwrvgnd_1
XFILLER_0_9_1343 VGND VGND VPWR VPWR sky130_fd_sc_hd__fill_1
XFILLER_0_189_1213 VPWR VGND VPWR VGND sky130_ef_sc_hd__decap_12
XTAP_2163 VGND VPWR sky130_fd_sc_hd__tapvpwrvgnd_1
XFILLER_0_111_1009 VPWR VGND VPWR VGND sky130_ef_sc_hd__decap_12
XFILLER_0_139_641 VGND VGND VPWR VPWR sky130_fd_sc_hd__decap_4
XTAP_2174 VGND VPWR sky130_fd_sc_hd__tapvpwrvgnd_1
XFILLER_0_61_39 VGND VGND VPWR VPWR sky130_fd_sc_hd__decap_8
XTAP_1440 VGND VPWR sky130_fd_sc_hd__tapvpwrvgnd_1
XFILLER_0_29_617 VPWR VGND VPWR VGND sky130_ef_sc_hd__decap_12
XTAP_1451 VGND VPWR sky130_fd_sc_hd__tapvpwrvgnd_1
XFILLER_0_55_1291 VPWR VGND VPWR VGND sky130_ef_sc_hd__decap_12
XTAP_2185 VGND VPWR sky130_fd_sc_hd__tapvpwrvgnd_1
XTAP_2196 VGND VPWR sky130_fd_sc_hd__tapvpwrvgnd_1
XTAP_1462 VGND VPWR sky130_fd_sc_hd__tapvpwrvgnd_1
XTAP_1473 VGND VPWR sky130_fd_sc_hd__tapvpwrvgnd_1
XTAP_1484 VGND VPWR sky130_fd_sc_hd__tapvpwrvgnd_1
XFILLER_0_16_1275 VGND VGND VPWR VPWR sky130_fd_sc_hd__decap_6
XFILLER_0_189_1279 VPWR VGND VPWR VGND sky130_ef_sc_hd__decap_12
XTAP_1495 VGND VPWR sky130_fd_sc_hd__tapvpwrvgnd_1
XFILLER_0_154_655 VGND VGND VPWR VPWR sky130_fd_sc_hd__decap_4
XFILLER_0_226_1118 VGND VGND VPWR VPWR sky130_fd_sc_hd__fill_2
XFILLER_0_3_205 VPWR VGND VPWR VGND sky130_ef_sc_hd__decap_12
XFILLER_0_52_631 VPWR VGND VPWR VGND sky130_ef_sc_hd__decap_12
XFILLER_0_101_34 VPWR VGND VPWR VGND sky130_ef_sc_hd__decap_12
XFILLER_0_3_249 VPWR VGND VPWR VGND sky130_ef_sc_hd__decap_12
XFILLER_0_126_1263 VPWR VGND VPWR VGND sky130_ef_sc_hd__decap_12
XFILLER_0_0_923 VGND VGND VPWR VPWR sky130_fd_sc_hd__fill_1
XFILLER_0_177_27 VPWR VGND VPWR VGND sky130_ef_sc_hd__decap_12
XFILLER_0_110_725 VPWR VGND VPWR VGND sky130_ef_sc_hd__decap_12
XFILLER_0_0_945 VGND VGND VPWR VPWR sky130_fd_sc_hd__decap_6
XFILLER_0_23_1213 VPWR VGND VPWR VGND sky130_ef_sc_hd__decap_12
XFILLER_0_62_1251 VPWR VGND VPWR VGND sky130_ef_sc_hd__decap_12
XFILLER_0_209_645 VGND VGND VPWR VPWR sky130_fd_sc_hd__fill_1
XFILLER_0_97_1303 VGND VGND VPWR VPWR sky130_fd_sc_hd__decap_6
XFILLER_0_110_769 VPWR VGND VPWR VGND sky130_ef_sc_hd__decap_12
XFILLER_0_62_1295 VPWR VGND VPWR VGND sky130_ef_sc_hd__decap_12
XFILLER_0_196_1239 VPWR VGND VPWR VGND sky130_ef_sc_hd__decap_12
XFILLER_0_23_1279 VPWR VGND VPWR VGND sky130_ef_sc_hd__decap_12
XFILLER_0_224_637 VGND VGND VPWR VPWR sky130_fd_sc_hd__decap_6
XFILLER_0_193_15 VPWR VGND VPWR VGND sky130_ef_sc_hd__decap_12
XFILLER_0_223_125 VPWR VGND VPWR VGND sky130_ef_sc_hd__decap_12
XFILLER_0_223_169 VPWR VGND VPWR VGND sky130_ef_sc_hd__decap_12
XFILLER_0_172_1283 VPWR VGND VPWR VGND sky130_ef_sc_hd__decap_12
XFILLER_0_133_1201 VPWR VGND VPWR VGND sky130_ef_sc_hd__decap_12
XFILLER_0_133_1267 VPWR VGND VPWR VGND sky130_ef_sc_hd__decap_12
XFILLER_0_34_1331 VGND VGND VPWR VPWR sky130_fd_sc_hd__decap_6
XFILLER_0_142_41 VGND VGND VPWR VPWR sky130_fd_sc_hd__decap_8
XFILLER_0_168_1319 VPWR VGND VPWR VGND sky130_ef_sc_hd__decap_12
XFILLER_0_7_533 VPWR VGND VPWR VGND sky130_ef_sc_hd__decap_12
XFILLER_0_30_1239 VPWR VGND VPWR VGND sky130_ef_sc_hd__decap_12
XFILLER_0_145_655 VGND VGND VPWR VPWR sky130_fd_sc_hd__fill_2
XFILLER_0_113_541 VPWR VGND VPWR VGND sky130_ef_sc_hd__decap_12
XFILLER_0_140_1227 VPWR VGND VPWR VGND sky130_ef_sc_hd__decap_12
XFILLER_0_105_1325 VPWR VGND VPWR VGND sky130_ef_sc_hd__decap_12
XFILLER_0_113_585 VPWR VGND VPWR VGND sky130_ef_sc_hd__decap_12
XFILLER_0_3_783 VGND VGND VPWR VPWR sky130_fd_sc_hd__fill_1
XFILLER_0_41_1335 VGND VGND VPWR VPWR sky130_fd_sc_hd__fill_1
XFILLER_0_220_1273 VPWR VGND VPWR VGND sky130_ef_sc_hd__decap_12
XFILLER_0_215_615 VGND VGND VPWR VPWR sky130_fd_sc_hd__fill_1
XFILLER_0_216_1309 VGND VGND VPWR VPWR sky130_fd_sc_hd__decap_6
XFILLER_0_39_1253 VGND VGND VPWR VPWR sky130_fd_sc_hd__fill_1
XFILLER_0_211_821 VPWR VGND VPWR VGND sky130_ef_sc_hd__decap_12
XFILLER_0_151_1323 VPWR VGND VPWR VGND sky130_ef_sc_hd__decap_12
XFILLER_0_211_865 VPWR VGND VPWR VGND sky130_ef_sc_hd__decap_12
XPHY_501 VGND VGND VPWR VPWR sky130_fd_sc_hd__decap_3
XFILLER_0_112_1329 VPWR VGND VPWR VGND sky130_ef_sc_hd__decap_12
XPHY_512 VGND VGND VPWR VPWR sky130_fd_sc_hd__decap_3
XPHY_534 VGND VGND VPWR VPWR sky130_fd_sc_hd__decap_3
XPHY_523 VGND VGND VPWR VPWR sky130_fd_sc_hd__decap_3
XPHY_1122 VGND VGND VPWR VPWR sky130_fd_sc_hd__decap_3
XPHY_1111 VGND VGND VPWR VPWR sky130_fd_sc_hd__decap_3
XPHY_1100 VGND VGND VPWR VPWR sky130_fd_sc_hd__decap_3
XPHY_578 VGND VGND VPWR VPWR sky130_fd_sc_hd__decap_3
XPHY_567 VGND VGND VPWR VPWR sky130_fd_sc_hd__decap_3
XPHY_545 VGND VGND VPWR VPWR sky130_fd_sc_hd__decap_3
XPHY_556 VGND VGND VPWR VPWR sky130_fd_sc_hd__decap_3
XPHY_1144 VGND VGND VPWR VPWR sky130_fd_sc_hd__decap_3
XPHY_1133 VGND VGND VPWR VPWR sky130_fd_sc_hd__decap_3
XPHY_1166 VGND VGND VPWR VPWR sky130_fd_sc_hd__decap_3
XPHY_1155 VGND VGND VPWR VPWR sky130_fd_sc_hd__decap_3
XFILLER_0_136_655 VGND VGND VPWR VPWR sky130_fd_sc_hd__decap_4
XPHY_589 VGND VGND VPWR VPWR sky130_fd_sc_hd__decap_3
XFILLER_0_4_1273 VPWR VGND VPWR VGND sky130_ef_sc_hd__decap_12
XFILLER_0_108_357 VGND VGND VPWR VPWR sky130_fd_sc_hd__decap_6
XPHY_1199 VGND VGND VPWR VPWR sky130_fd_sc_hd__decap_3
XPHY_1177 VGND VGND VPWR VPWR sky130_fd_sc_hd__decap_3
XPHY_1188 VGND VGND VPWR VPWR sky130_fd_sc_hd__decap_3
XFILLER_0_34_631 VPWR VGND VPWR VGND sky130_ef_sc_hd__decap_12
XFILLER_0_151_647 VGND VGND VPWR VPWR sky130_fd_sc_hd__decap_8
XFILLER_0_1_709 VPWR VGND VPWR VGND sky130_ef_sc_hd__decap_12
XFILLER_0_46_1213 VPWR VGND VPWR VGND sky130_ef_sc_hd__decap_12
XANTENNA_input60_A psum_col0_in[4] VGND VGND VPWR VPWR sky130_fd_sc_hd__diode_2
XFILLER_0_0_219 VGND VGND VPWR VPWR sky130_fd_sc_hd__decap_4
XFILLER_0_104_585 VGND VGND VPWR VPWR sky130_fd_sc_hd__decap_3
XFILLER_0_219_921 VPWR VGND VPWR VGND sky130_ef_sc_hd__decap_12
XFILLER_0_219_965 VPWR VGND VPWR VGND sky130_ef_sc_hd__decap_12
XFILLER_0_218_475 VGND VGND VPWR VPWR sky130_fd_sc_hd__fill_1
XFILLER_0_156_1201 VPWR VGND VPWR VGND sky130_ef_sc_hd__decap_12
XFILLER_0_221_629 VPWR VGND VPWR VGND sky130_ef_sc_hd__decap_12
XFILLER_0_214_681 VPWR VGND VPWR VGND sky130_ef_sc_hd__decap_12
XFILLER_0_220_139 VGND VGND VPWR VPWR sky130_fd_sc_hd__fill_1
XFILLER_0_72_49 VGND VGND VPWR VPWR sky130_fd_sc_hd__fill_1
XFILLER_0_72_27 VGND VGND VPWR VPWR sky130_fd_sc_hd__fill_1
XFILLER_0_18_1337 VGND VGND VPWR VPWR sky130_fd_sc_hd__fill_1
XTAP_1281 VGND VPWR sky130_fd_sc_hd__tapvpwrvgnd_1
XTAP_1270 VGND VPWR sky130_fd_sc_hd__tapvpwrvgnd_1
XTAP_1292 VGND VPWR sky130_fd_sc_hd__tapvpwrvgnd_1
XFILLER_0_127_655 VGND VGND VPWR VPWR sky130_fd_sc_hd__fill_2
XFILLER_0_112_22 VGND VGND VPWR VPWR sky130_fd_sc_hd__decap_6
XFILLER_0_4_525 VGND VGND VPWR VPWR sky130_fd_sc_hd__decap_6
XFILLER_0_112_77 VGND VGND VPWR VPWR sky130_fd_sc_hd__decap_6
XFILLER_0_114_305 VGND VGND VPWR VPWR sky130_fd_sc_hd__decap_3
XFILLER_0_188_15 VPWR VGND VPWR VGND sky130_ef_sc_hd__decap_12
XFILLER_0_114_349 VPWR VGND VPWR VGND sky130_ef_sc_hd__decap_12
XFILLER_0_204_1213 VPWR VGND VPWR VGND sky130_ef_sc_hd__decap_12
XFILLER_0_163_1249 VGND VGND VPWR VPWR sky130_fd_sc_hd__decap_4
XFILLER_0_4_569 VPWR VGND VPWR VGND sky130_ef_sc_hd__decap_12
XFILLER_0_110_533 VPWR VGND VPWR VGND sky130_ef_sc_hd__decap_12
XFILLER_0_224_401 VPWR VGND VPWR VGND sky130_ef_sc_hd__decap_12
XFILLER_0_224_445 VPWR VGND VPWR VGND sky130_ef_sc_hd__decap_12
XANTENNA_u_pe10_weight_in[8] net147 VGND VGND VPWR VPWR sky130_fd_sc_hd__diode_2
XFILLER_0_224_489 VPWR VGND VPWR VGND sky130_ef_sc_hd__decap_12
XFILLER_0_118_655 VGND VGND VPWR VPWR sky130_fd_sc_hd__decap_4
XFILLER_0_69_1213 VPWR VGND VPWR VGND sky130_ef_sc_hd__decap_12
XFILLER_0_16_631 VPWR VGND VPWR VGND sky130_ef_sc_hd__decap_12
XFILLER_0_105_305 VPWR VGND VPWR VGND sky130_ef_sc_hd__decap_12
XFILLER_0_133_647 VGND VGND VPWR VPWR sky130_fd_sc_hd__decap_8
XFILLER_0_7_385 VGND VGND VPWR VPWR sky130_fd_sc_hd__fill_2
XFILLER_0_69_1279 VPWR VGND VPWR VGND sky130_ef_sc_hd__decap_12
XFILLER_0_105_349 VPWR VGND VPWR VGND sky130_ef_sc_hd__decap_12
XFILLER_0_31_645 VGND VGND VPWR VPWR sky130_fd_sc_hd__fill_1
XFILLER_0_179_1201 VPWR VGND VPWR VGND sky130_ef_sc_hd__decap_12
XFILLER_0_219_217 VGND VGND VPWR VPWR sky130_fd_sc_hd__decap_6
XFILLER_0_105_1133 VPWR VGND VPWR VGND sky130_ef_sc_hd__decap_12
XFILLER_0_113_393 VPWR VGND VPWR VGND sky130_ef_sc_hd__decap_12
XFILLER_0_105_1177 VPWR VGND VPWR VGND sky130_ef_sc_hd__decap_12
XFILLER_0_179_1267 VPWR VGND VPWR VGND sky130_ef_sc_hd__decap_12
XFILLER_0_216_979 VGND VGND VPWR VPWR sky130_fd_sc_hd__fill_1
XFILLER_0_216_1117 VPWR VGND VPWR VGND sky130_ef_sc_hd__decap_12
XFILLER_0_203_629 VPWR VGND VPWR VGND sky130_ef_sc_hd__decap_12
XFILLER_0_76_1239 VPWR VGND VPWR VGND sky130_ef_sc_hd__decap_12
XFILLER_0_116_1251 VPWR VGND VPWR VGND sky130_ef_sc_hd__decap_12
XFILLER_0_211_673 VPWR VGND VPWR VGND sky130_ef_sc_hd__decap_12
XFILLER_0_13_1201 VPWR VGND VPWR VGND sky130_ef_sc_hd__decap_12
XFILLER_0_116_1295 VPWR VGND VPWR VGND sky130_ef_sc_hd__decap_12
XPHY_331 VGND VGND VPWR VPWR sky130_fd_sc_hd__decap_3
XPHY_342 VGND VGND VPWR VPWR sky130_fd_sc_hd__decap_3
XFILLER_0_52_1283 VPWR VGND VPWR VGND sky130_ef_sc_hd__decap_12
XPHY_320 VGND VGND VPWR VPWR sky130_fd_sc_hd__decap_3
XFILLER_0_186_1227 VPWR VGND VPWR VGND sky130_ef_sc_hd__decap_12
XPHY_364 VGND VGND VPWR VPWR sky130_fd_sc_hd__decap_3
XPHY_353 VGND VGND VPWR VPWR sky130_fd_sc_hd__decap_3
XFILLER_0_13_1267 VPWR VGND VPWR VGND sky130_ef_sc_hd__decap_12
XPHY_375 VGND VGND VPWR VPWR sky130_fd_sc_hd__decap_3
XPHY_386 VGND VGND VPWR VPWR sky130_fd_sc_hd__decap_3
XFILLER_0_108_121 VPWR VGND VPWR VGND sky130_ef_sc_hd__decap_12
XPHY_397 VGND VGND VPWR VPWR sky130_fd_sc_hd__decap_3
XFILLER_0_87_1335 VGND VGND VPWR VPWR sky130_fd_sc_hd__decap_8
XFILLER_0_108_165 VPWR VGND VPWR VGND sky130_ef_sc_hd__decap_12
XFILLER_0_48_1319 VPWR VGND VPWR VGND sky130_ef_sc_hd__decap_12
XFILLER_0_1_517 VPWR VGND VPWR VGND sky130_ef_sc_hd__decap_12
XFILLER_0_67_27 VPWR VGND VPWR VGND sky130_ef_sc_hd__decap_12
XFILLER_0_158_29 VPWR VGND VPWR VGND sky130_ef_sc_hd__decap_12
XFILLER_0_197_1323 VGND VGND VPWR VPWR sky130_fd_sc_hd__decap_8
XFILLER_0_123_1255 VPWR VGND VPWR VGND sky130_ef_sc_hd__decap_12
XFILLER_0_158_1307 VPWR VGND VPWR VGND sky130_ef_sc_hd__decap_12
XFILLER_0_20_1227 VPWR VGND VPWR VGND sky130_ef_sc_hd__decap_12
XFILLER_0_83_15 VPWR VGND VPWR VGND sky130_ef_sc_hd__decap_12
XFILLER_0_222_905 VPWR VGND VPWR VGND sky130_ef_sc_hd__decap_12
XFILLER_0_94_1339 VGND VGND VPWR VPWR sky130_fd_sc_hd__decap_4
XFILLER_0_222_949 VPWR VGND VPWR VGND sky130_ef_sc_hd__decap_12
XFILLER_0_89_645 VGND VGND VPWR VPWR sky130_fd_sc_hd__fill_1
XFILLER_0_107_55 VGND VGND VPWR VPWR sky130_fd_sc_hd__fill_1
XFILLER_0_190_49 VGND VGND VPWR VPWR sky130_fd_sc_hd__fill_1
XFILLER_0_190_27 VGND VGND VPWR VPWR sky130_fd_sc_hd__fill_1
XFILLER_0_9_617 VPWR VGND VPWR VGND sky130_ef_sc_hd__decap_12
XFILLER_0_31_1323 VPWR VGND VPWR VGND sky130_ef_sc_hd__decap_12
XFILLER_0_210_1261 VPWR VGND VPWR VGND sky130_ef_sc_hd__decap_12
XFILLER_0_32_41 VGND VGND VPWR VPWR sky130_fd_sc_hd__decap_8
XFILLER_0_199_25 VPWR VGND VPWR VGND sky130_ef_sc_hd__decap_12
XFILLER_0_115_647 VPWR VGND VPWR VGND sky130_ef_sc_hd__decap_12
XFILLER_0_4_333 VPWR VGND VPWR VGND sky130_ef_sc_hd__decap_12
XFILLER_0_114_113 VPWR VGND VPWR VGND sky130_ef_sc_hd__decap_12
XFILLER_0_206_1319 VPWR VGND VPWR VGND sky130_ef_sc_hd__decap_12
XFILLER_0_130_617 VGND VGND VPWR VPWR sky130_fd_sc_hd__fill_1
XFILLER_0_5_889 VGND VGND VPWR VPWR sky130_fd_sc_hd__decap_6
XFILLER_0_13_645 VGND VGND VPWR VPWR sky130_fd_sc_hd__fill_1
XFILLER_0_141_1311 VPWR VGND VPWR VGND sky130_ef_sc_hd__decap_12
XFILLER_0_4_377 VPWR VGND VPWR VGND sky130_ef_sc_hd__decap_12
XFILLER_0_111_853 VPWR VGND VPWR VGND sky130_ef_sc_hd__decap_12
XFILLER_0_111_897 VPWR VGND VPWR VGND sky130_ef_sc_hd__decap_12
XFILLER_0_0_561 VPWR VGND VPWR VGND sky130_ef_sc_hd__decap_12
XFILLER_0_110_363 VGND VGND VPWR VPWR sky130_fd_sc_hd__fill_1
XFILLER_0_216_209 VPWR VGND VPWR VGND sky130_ef_sc_hd__decap_12
XFILLER_0_102_1339 VGND VGND VPWR VPWR sky130_fd_sc_hd__decap_4
XFILLER_0_225_721 VGND VGND VPWR VPWR sky130_fd_sc_hd__decap_6
XFILLER_0_225_765 VPWR VGND VPWR VGND sky130_ef_sc_hd__decap_12
XFILLER_0_224_253 VPWR VGND VPWR VGND sky130_ef_sc_hd__decap_12
XTAP_2707 VGND VPWR sky130_fd_sc_hd__tapvpwrvgnd_1
XTAP_2718 VGND VPWR sky130_fd_sc_hd__tapvpwrvgnd_1
XFILLER_0_197_617 VPWR VGND VPWR VGND sky130_ef_sc_hd__decap_12
XFILLER_0_36_1201 VPWR VGND VPWR VGND sky130_ef_sc_hd__decap_12
XTAP_2729 VGND VPWR sky130_fd_sc_hd__tapvpwrvgnd_1
XFILLER_0_106_625 VPWR VGND VPWR VGND sky130_ef_sc_hd__decap_12
XFILLER_0_7_193 VGND VGND VPWR VPWR sky130_fd_sc_hd__decap_3
XFILLER_0_1_1287 VGND VGND VPWR VPWR sky130_fd_sc_hd__fill_1
XFILLER_0_105_113 VPWR VGND VPWR VGND sky130_ef_sc_hd__decap_12
XFILLER_0_121_617 VPWR VGND VPWR VGND sky130_ef_sc_hd__decap_12
XFILLER_0_106_669 VPWR VGND VPWR VGND sky130_ef_sc_hd__decap_12
XANTENNA_input162_A w11[7] VGND VGND VPWR VPWR sky130_fd_sc_hd__diode_2
XFILLER_0_9_3 VPWR VGND VPWR VGND sky130_ef_sc_hd__decap_12
XFILLER_0_43_1249 VGND VGND VPWR VPWR sky130_fd_sc_hd__decap_4
Xinput100 valid_row1_in VGND VGND VPWR VPWR net100 sky130_fd_sc_hd__clkbuf_2
Xinput111 w00[4] VGND VGND VPWR VPWR net111 sky130_fd_sc_hd__buf_1
Xinput144 w10[5] VGND VGND VPWR VPWR net144 sky130_fd_sc_hd__clkbuf_4
Xinput133 w10[0] VGND VGND VPWR VPWR net133 sky130_fd_sc_hd__clkbuf_4
Xinput122 w01[14] VGND VGND VPWR VPWR net122 sky130_fd_sc_hd__clkbuf_4
Xinput155 w11[15] VGND VGND VPWR VPWR net155 sky130_fd_sc_hd__clkbuf_8
XANTENNA_input23_A act_row1_in[15] VGND VGND VPWR VPWR sky130_fd_sc_hd__diode_2
XFILLER_0_192_1275 VGND VGND VPWR VPWR sky130_fd_sc_hd__decap_6
XFILLER_0_188_617 VGND VGND VPWR VPWR sky130_fd_sc_hd__fill_1
XFILLER_0_153_1237 VPWR VGND VPWR VGND sky130_ef_sc_hd__decap_12
XFILLER_0_212_993 VPWR VGND VPWR VGND sky130_ef_sc_hd__decap_12
XFILLER_0_224_53 VPWR VGND VPWR VGND sky130_ef_sc_hd__decap_12
XFILLER_0_224_97 VPWR VGND VPWR VGND sky130_ef_sc_hd__decap_12
XPHY_161 VGND VGND VPWR VPWR sky130_fd_sc_hd__decap_3
XPHY_150 VGND VGND VPWR VPWR sky130_fd_sc_hd__decap_3
XFILLER_0_2_1029 VGND VGND VPWR VPWR sky130_fd_sc_hd__decap_6
XFILLER_0_109_441 VGND VGND VPWR VPWR sky130_fd_sc_hd__decap_6
XPHY_172 VGND VGND VPWR VPWR sky130_fd_sc_hd__decap_3
XPHY_183 VGND VGND VPWR VPWR sky130_fd_sc_hd__decap_3
XPHY_194 VGND VGND VPWR VPWR sky130_fd_sc_hd__decap_3
XFILLER_0_109_485 VPWR VGND VPWR VGND sky130_ef_sc_hd__decap_12
XFILLER_0_78_15 VPWR VGND VPWR VGND sky130_ef_sc_hd__decap_12
XFILLER_0_2_837 VPWR VGND VPWR VGND sky130_ef_sc_hd__decap_12
XFILLER_0_111_105 VGND VGND VPWR VPWR sky130_fd_sc_hd__decap_6
XFILLER_0_169_39 VGND VGND VPWR VPWR sky130_fd_sc_hd__decap_8
XFILLER_0_111_149 VPWR VGND VPWR VGND sky130_ef_sc_hd__decap_12
XFILLER_0_201_1249 VGND VGND VPWR VPWR sky130_fd_sc_hd__decap_4
XFILLER_0_59_1201 VPWR VGND VPWR VGND sky130_ef_sc_hd__decap_12
XFILLER_0_98_1283 VPWR VGND VPWR VGND sky130_ef_sc_hd__decap_12
XFILLER_0_222_713 VPWR VGND VPWR VGND sky130_ef_sc_hd__decap_12
XFILLER_0_179_617 VPWR VGND VPWR VGND sky130_ef_sc_hd__decap_12
XFILLER_0_59_1267 VPWR VGND VPWR VGND sky130_ef_sc_hd__decap_12
XFILLER_0_222_757 VPWR VGND VPWR VGND sky130_ef_sc_hd__decap_12
XFILLER_0_221_223 VGND VGND VPWR VPWR sky130_fd_sc_hd__fill_1
XFILLER_0_169_1255 VPWR VGND VPWR VGND sky130_ef_sc_hd__decap_12
XFILLER_0_150_41 VGND VGND VPWR VPWR sky130_fd_sc_hd__decap_8
XFILLER_0_4_141 VPWR VGND VPWR VGND sky130_ef_sc_hd__decap_12
XFILLER_0_5_653 VPWR VGND VPWR VGND sky130_ef_sc_hd__decap_12
XFILLER_0_66_1227 VPWR VGND VPWR VGND sky130_ef_sc_hd__decap_12
XFILLER_0_103_617 VPWR VGND VPWR VGND sky130_ef_sc_hd__decap_12
XFILLER_0_5_697 VPWR VGND VPWR VGND sky130_ef_sc_hd__decap_12
XFILLER_0_106_1261 VPWR VGND VPWR VGND sky130_ef_sc_hd__decap_12
XFILLER_0_217_529 VPWR VGND VPWR VGND sky130_ef_sc_hd__decap_12
XFILLER_0_0_391 VGND VGND VPWR VPWR sky130_fd_sc_hd__fill_1
XFILLER_0_217_1201 VPWR VGND VPWR VGND sky130_ef_sc_hd__decap_12
XFILLER_0_77_1323 VPWR VGND VPWR VGND sky130_ef_sc_hd__decap_12
XFILLER_0_225_573 VPWR VGND VPWR VGND sky130_ef_sc_hd__decap_12
XFILLER_0_38_1307 VPWR VGND VPWR VGND sky130_ef_sc_hd__decap_12
XFILLER_0_217_1245 VPWR VGND VPWR VGND sky130_ef_sc_hd__decap_12
XTAP_2515 VGND VPWR sky130_fd_sc_hd__tapvpwrvgnd_1
XTAP_2504 VGND VPWR sky130_fd_sc_hd__tapvpwrvgnd_1
XFILLER_0_212_245 VGND VGND VPWR VPWR sky130_fd_sc_hd__decap_6
XTAP_2526 VGND VPWR sky130_fd_sc_hd__tapvpwrvgnd_1
XFILLER_0_217_1289 VPWR VGND VPWR VGND sky130_ef_sc_hd__decap_12
XTAP_2559 VGND VPWR sky130_fd_sc_hd__tapvpwrvgnd_1
XTAP_2548 VGND VPWR sky130_fd_sc_hd__tapvpwrvgnd_1
XTAP_2537 VGND VPWR sky130_fd_sc_hd__tapvpwrvgnd_1
XFILLER_0_212_289 VPWR VGND VPWR VGND sky130_ef_sc_hd__decap_12
XTAP_1825 VGND VPWR sky130_fd_sc_hd__tapvpwrvgnd_1
XTAP_1803 VGND VPWR sky130_fd_sc_hd__tapvpwrvgnd_1
XTAP_1814 VGND VPWR sky130_fd_sc_hd__tapvpwrvgnd_1
XFILLER_0_152_1281 VGND VGND VPWR VPWR sky130_fd_sc_hd__fill_1
XTAP_1836 VGND VPWR sky130_fd_sc_hd__tapvpwrvgnd_1
XTAP_1858 VGND VPWR sky130_fd_sc_hd__tapvpwrvgnd_1
XTAP_1847 VGND VPWR sky130_fd_sc_hd__tapvpwrvgnd_1
XFILLER_0_187_1311 VPWR VGND VPWR VGND sky130_ef_sc_hd__decap_12
XTAP_1869 VGND VPWR sky130_fd_sc_hd__tapvpwrvgnd_1
XFILLER_0_83_629 VPWR VGND VPWR VGND sky130_ef_sc_hd__decap_12
XFILLER_0_113_1287 VGND VGND VPWR VPWR sky130_fd_sc_hd__fill_1
XFILLER_0_148_1339 VGND VGND VPWR VPWR sky130_fd_sc_hd__decap_4
XFILLER_0_107_945 VGND VGND VPWR VPWR sky130_fd_sc_hd__decap_6
XFILLER_0_106_433 VPWR VGND VPWR VGND sky130_ef_sc_hd__decap_12
XFILLER_0_224_1205 VPWR VGND VPWR VGND sky130_ef_sc_hd__decap_12
XFILLER_0_107_989 VPWR VGND VPWR VGND sky130_ef_sc_hd__decap_12
XANTENNA_u_pe10_rst_n net98 VGND VGND VPWR VPWR sky130_fd_sc_hd__diode_2
XFILLER_0_106_477 VPWR VGND VPWR VGND sky130_ef_sc_hd__decap_12
XFILLER_0_48_29 VPWR VGND VPWR VGND sky130_ef_sc_hd__decap_12
XFILLER_0_120_1225 VGND VGND VPWR VPWR sky130_fd_sc_hd__fill_1
XFILLER_0_21_1311 VPWR VGND VPWR VGND sky130_ef_sc_hd__decap_12
XFILLER_0_194_1337 VGND VGND VPWR VPWR sky130_fd_sc_hd__fill_1
XFILLER_0_91_1309 VGND VGND VPWR VPWR sky130_fd_sc_hd__fill_1
XFILLER_0_8_1227 VPWR VGND VPWR VGND sky130_ef_sc_hd__decap_12
XANTENNA_u_pe10_act_in[15] net23 VGND VGND VPWR VPWR sky130_fd_sc_hd__diode_2
XFILLER_0_147_6 VGND VGND VPWR VPWR sky130_fd_sc_hd__fill_2
XFILLER_0_184_631 VPWR VGND VPWR VGND sky130_ef_sc_hd__decap_12
XFILLER_0_80_49 VGND VGND VPWR VPWR sky130_fd_sc_hd__fill_1
XFILLER_0_89_1249 VGND VGND VPWR VPWR sky130_fd_sc_hd__decap_4
XFILLER_0_89_47 VGND VGND VPWR VPWR sky130_fd_sc_hd__fill_1
XFILLER_0_109_293 VPWR VGND VPWR VGND sky130_ef_sc_hd__decap_12
XFILLER_0_2_601 VPWR VGND VPWR VGND sky130_ef_sc_hd__decap_12
XFILLER_0_2_645 VPWR VGND VPWR VGND sky130_ef_sc_hd__decap_12
XFILLER_0_1_111 VGND VGND VPWR VPWR sky130_fd_sc_hd__fill_1
XFILLER_0_199_1237 VPWR VGND VPWR VGND sky130_ef_sc_hd__decap_12
XFILLER_0_112_469 VGND VGND VPWR VPWR sky130_fd_sc_hd__decap_6
XFILLER_0_226_304 VGND VGND VPWR VPWR sky130_fd_sc_hd__decap_4
XFILLER_0_226_337 VPWR VGND VPWR VGND sky130_ef_sc_hd__decap_12
XFILLER_0_222_587 VGND VGND VPWR VPWR sky130_fd_sc_hd__fill_1
XFILLER_0_72_1275 VGND VGND VPWR VPWR sky130_fd_sc_hd__decap_6
XPHY_908 VGND VGND VPWR VPWR sky130_fd_sc_hd__decap_3
XPHY_919 VGND VGND VPWR VPWR sky130_fd_sc_hd__decap_3
XFILLER_0_65_629 VPWR VGND VPWR VGND sky130_ef_sc_hd__decap_12
XFILLER_0_33_1237 VPWR VGND VPWR VGND sky130_ef_sc_hd__decap_12
XFILLER_0_212_1197 VGND VGND VPWR VPWR sky130_fd_sc_hd__decap_6
XFILLER_0_6_973 VGND VGND VPWR VPWR sky130_fd_sc_hd__decap_6
XFILLER_0_104_937 VPWR VGND VPWR VGND sky130_ef_sc_hd__decap_12
XFILLER_0_5_461 VPWR VGND VPWR VGND sky130_ef_sc_hd__decap_12
XFILLER_0_182_1263 VPWR VGND VPWR VGND sky130_ef_sc_hd__decap_12
XFILLER_0_143_1225 VPWR VGND VPWR VGND sky130_ef_sc_hd__decap_12
XFILLER_0_112_981 VPWR VGND VPWR VGND sky130_ef_sc_hd__decap_12
XFILLER_0_218_805 VGND VGND VPWR VPWR sky130_fd_sc_hd__decap_6
XFILLER_0_218_849 VPWR VGND VPWR VGND sky130_ef_sc_hd__decap_12
XFILLER_0_217_337 VPWR VGND VPWR VGND sky130_ef_sc_hd__decap_12
XFILLER_0_106_1091 VGND VGND VPWR VPWR sky130_fd_sc_hd__fill_1
XTAP_2301 VGND VPWR sky130_fd_sc_hd__tapvpwrvgnd_1
XANTENNA_input125_A w01[2] VGND VGND VPWR VPWR sky130_fd_sc_hd__diode_2
XTAP_2323 VGND VPWR sky130_fd_sc_hd__tapvpwrvgnd_1
XTAP_2312 VGND VPWR sky130_fd_sc_hd__tapvpwrvgnd_1
XFILLER_0_154_1343 VGND VGND VPWR VPWR sky130_fd_sc_hd__fill_1
XFILLER_0_90_1331 VGND VGND VPWR VPWR sky130_fd_sc_hd__decap_6
XTAP_2334 VGND VPWR sky130_fd_sc_hd__tapvpwrvgnd_1
XTAP_1600 VGND VPWR sky130_fd_sc_hd__tapvpwrvgnd_1
XTAP_2367 VGND VPWR sky130_fd_sc_hd__tapvpwrvgnd_1
XTAP_2356 VGND VPWR sky130_fd_sc_hd__tapvpwrvgnd_1
XTAP_2378 VGND VPWR sky130_fd_sc_hd__tapvpwrvgnd_1
XTAP_1622 VGND VPWR sky130_fd_sc_hd__tapvpwrvgnd_1
XTAP_1611 VGND VPWR sky130_fd_sc_hd__tapvpwrvgnd_1
XTAP_1633 VGND VPWR sky130_fd_sc_hd__tapvpwrvgnd_1
XTAP_2345 VGND VPWR sky130_fd_sc_hd__tapvpwrvgnd_1
XTAP_2389 VGND VPWR sky130_fd_sc_hd__tapvpwrvgnd_1
XFILLER_0_166_631 VPWR VGND VPWR VGND sky130_ef_sc_hd__decap_12
XTAP_1666 VGND VPWR sky130_fd_sc_hd__tapvpwrvgnd_1
XFILLER_0_3_1113 VGND VGND VPWR VPWR sky130_fd_sc_hd__decap_6
XTAP_1644 VGND VPWR sky130_fd_sc_hd__tapvpwrvgnd_1
XTAP_1655 VGND VPWR sky130_fd_sc_hd__tapvpwrvgnd_1
XTAP_1677 VGND VPWR sky130_fd_sc_hd__tapvpwrvgnd_1
XTAP_1688 VGND VPWR sky130_fd_sc_hd__tapvpwrvgnd_1
XTAP_1699 VGND VPWR sky130_fd_sc_hd__tapvpwrvgnd_1
XANTENNA_input90_A psum_col1_in[31] VGND VGND VPWR VPWR sky130_fd_sc_hd__diode_2
XFILLER_0_181_645 VGND VGND VPWR VPWR sky130_fd_sc_hd__fill_1
XFILLER_0_3_1157 VPWR VGND VPWR VGND sky130_ef_sc_hd__decap_12
XFILLER_0_107_753 VPWR VGND VPWR VGND sky130_ef_sc_hd__decap_12
XFILLER_0_107_797 VPWR VGND VPWR VGND sky130_ef_sc_hd__decap_12
XFILLER_0_49_1255 VPWR VGND VPWR VGND sky130_ef_sc_hd__decap_12
XFILLER_0_224_1035 VGND VGND VPWR VPWR sky130_fd_sc_hd__fill_1
XFILLER_0_161_1303 VGND VGND VPWR VPWR sky130_fd_sc_hd__decap_6
XFILLER_0_75_27 VPWR VGND VPWR VGND sky130_ef_sc_hd__decap_12
XFILLER_0_166_29 VPWR VGND VPWR VGND sky130_ef_sc_hd__decap_12
XFILLER_0_198_1281 VGND VGND VPWR VPWR sky130_fd_sc_hd__fill_1
XFILLER_0_223_329 VGND VGND VPWR VPWR sky130_fd_sc_hd__decap_6
XFILLER_0_95_1253 VGND VGND VPWR VPWR sky130_fd_sc_hd__fill_1
XTAP_2890 VGND VPWR sky130_fd_sc_hd__tapvpwrvgnd_1
XFILLER_0_47_629 VPWR VGND VPWR VGND sky130_ef_sc_hd__decap_12
XFILLER_0_145_3 VPWR VGND VPWR VGND sky130_ef_sc_hd__decap_12
XFILLER_0_32_1281 VGND VGND VPWR VPWR sky130_fd_sc_hd__fill_1
XFILLER_0_166_1225 VGND VGND VPWR VPWR sky130_fd_sc_hd__fill_1
XFILLER_0_40_41 VGND VGND VPWR VPWR sky130_fd_sc_hd__decap_8
XFILLER_0_67_1311 VPWR VGND VPWR VGND sky130_ef_sc_hd__decap_12
XFILLER_0_3_921 VPWR VGND VPWR VGND sky130_ef_sc_hd__decap_12
XFILLER_0_70_643 VPWR VGND VPWR VGND sky130_ef_sc_hd__decap_12
XFILLER_0_207_1255 VPWR VGND VPWR VGND sky130_ef_sc_hd__decap_12
Xoutput201 net201 VGND VGND VPWR VPWR psum_col1_out[13] sky130_fd_sc_hd__clkbuf_4
XFILLER_0_3_965 VPWR VGND VPWR VGND sky130_ef_sc_hd__decap_12
XFILLER_0_28_1339 VGND VGND VPWR VPWR sky130_fd_sc_hd__decap_4
XFILLER_0_112_233 VPWR VGND VPWR VGND sky130_ef_sc_hd__decap_12
Xoutput223 net223 VGND VGND VPWR VPWR psum_col1_out[4] sky130_fd_sc_hd__clkbuf_4
XFILLER_0_2_475 VGND VGND VPWR VPWR sky130_fd_sc_hd__fill_1
Xoutput212 net212 VGND VGND VPWR VPWR psum_col1_out[23] sky130_fd_sc_hd__clkbuf_4
XFILLER_0_112_277 VPWR VGND VPWR VGND sky130_ef_sc_hd__decap_12
XFILLER_0_103_1253 VGND VGND VPWR VPWR sky130_fd_sc_hd__fill_1
XFILLER_0_177_1343 VGND VGND VPWR VPWR sky130_fd_sc_hd__fill_1
XFILLER_0_4_41 VPWR VGND VPWR VGND sky130_ef_sc_hd__decap_12
XFILLER_0_214_307 VGND VGND VPWR VPWR sky130_fd_sc_hd__fill_1
XFILLER_0_4_85 VPWR VGND VPWR VGND sky130_ef_sc_hd__decap_12
XFILLER_0_223_841 VPWR VGND VPWR VGND sky130_ef_sc_hd__decap_12
XFILLER_0_74_1337 VGND VGND VPWR VPWR sky130_fd_sc_hd__fill_1
XFILLER_0_214_1259 VGND VGND VPWR VPWR sky130_fd_sc_hd__fill_1
XPHY_727 VGND VGND VPWR VPWR sky130_fd_sc_hd__decap_3
XFILLER_0_148_631 VPWR VGND VPWR VGND sky130_ef_sc_hd__decap_12
XPHY_705 VGND VGND VPWR VPWR sky130_fd_sc_hd__decap_3
XPHY_716 VGND VGND VPWR VPWR sky130_fd_sc_hd__decap_3
XPHY_738 VGND VGND VPWR VPWR sky130_fd_sc_hd__decap_3
XPHY_749 VGND VGND VPWR VPWR sky130_fd_sc_hd__decap_3
XFILLER_0_163_645 VGND VGND VPWR VPWR sky130_fd_sc_hd__fill_1
XFILLER_0_145_1309 VGND VGND VPWR VPWR sky130_fd_sc_hd__fill_1
XFILLER_0_104_701 VPWR VGND VPWR VGND sky130_ef_sc_hd__decap_12
XFILLER_0_6_781 VPWR VGND VPWR VGND sky130_ef_sc_hd__decap_12
XFILLER_0_108_1197 VGND VGND VPWR VPWR sky130_fd_sc_hd__decap_6
XFILLER_0_218_613 VPWR VGND VPWR VGND sky130_ef_sc_hd__decap_12
XFILLER_0_218_657 VPWR VGND VPWR VGND sky130_ef_sc_hd__decap_12
XFILLER_0_79_1237 VPWR VGND VPWR VGND sky130_ef_sc_hd__decap_12
XFILLER_0_217_167 VGND VGND VPWR VPWR sky130_fd_sc_hd__fill_1
XFILLER_0_216_65 VPWR VGND VPWR VGND sky130_ef_sc_hd__decap_12
XFILLER_0_9_1311 VPWR VGND VPWR VGND sky130_ef_sc_hd__decap_12
XFILLER_0_213_373 VPWR VGND VPWR VGND sky130_ef_sc_hd__decap_12
XTAP_2131 VGND VPWR sky130_fd_sc_hd__tapvpwrvgnd_1
XTAP_2120 VGND VPWR sky130_fd_sc_hd__tapvpwrvgnd_1
XTAP_2142 VGND VPWR sky130_fd_sc_hd__tapvpwrvgnd_1
XTAP_2153 VGND VPWR sky130_fd_sc_hd__tapvpwrvgnd_1
XFILLER_0_189_1225 VPWR VGND VPWR VGND sky130_ef_sc_hd__decap_12
XTAP_2175 VGND VPWR sky130_fd_sc_hd__tapvpwrvgnd_1
XTAP_2164 VGND VPWR sky130_fd_sc_hd__tapvpwrvgnd_1
XTAP_2186 VGND VPWR sky130_fd_sc_hd__tapvpwrvgnd_1
XTAP_1430 VGND VPWR sky130_fd_sc_hd__tapvpwrvgnd_1
XFILLER_0_29_629 VPWR VGND VPWR VGND sky130_ef_sc_hd__decap_12
XTAP_1441 VGND VPWR sky130_fd_sc_hd__tapvpwrvgnd_1
XTAP_2197 VGND VPWR sky130_fd_sc_hd__tapvpwrvgnd_1
XTAP_1474 VGND VPWR sky130_fd_sc_hd__tapvpwrvgnd_1
XTAP_1452 VGND VPWR sky130_fd_sc_hd__tapvpwrvgnd_1
XTAP_1463 VGND VPWR sky130_fd_sc_hd__tapvpwrvgnd_1
XTAP_1485 VGND VPWR sky130_fd_sc_hd__tapvpwrvgnd_1
XTAP_1496 VGND VPWR sky130_fd_sc_hd__tapvpwrvgnd_1
XFILLER_0_107_561 VPWR VGND VPWR VGND sky130_ef_sc_hd__decap_12
XFILLER_0_3_217 VGND VGND VPWR VPWR sky130_fd_sc_hd__decap_6
XFILLER_0_52_643 VPWR VGND VPWR VGND sky130_ef_sc_hd__decap_12
XFILLER_0_101_46 VGND VGND VPWR VPWR sky130_fd_sc_hd__decap_4
XFILLER_0_165_1291 VPWR VGND VPWR VGND sky130_ef_sc_hd__decap_12
XFILLER_0_177_39 VGND VGND VPWR VPWR sky130_fd_sc_hd__decap_8
XFILLER_0_126_1275 VGND VGND VPWR VPWR sky130_fd_sc_hd__decap_6
XFILLER_0_110_737 VPWR VGND VPWR VGND sky130_ef_sc_hd__decap_12
XFILLER_0_86_15 VPWR VGND VPWR VGND sky130_ef_sc_hd__decap_12
XFILLER_0_62_1263 VPWR VGND VPWR VGND sky130_ef_sc_hd__decap_12
XFILLER_0_23_1225 VPWR VGND VPWR VGND sky130_ef_sc_hd__decap_12
XFILLER_0_193_27 VPWR VGND VPWR VGND sky130_ef_sc_hd__decap_12
XFILLER_0_223_137 VPWR VGND VPWR VGND sky130_ef_sc_hd__decap_12
XFILLER_0_126_10 VPWR VGND VPWR VGND sky130_ef_sc_hd__decap_12
XFILLER_0_220_811 VGND VGND VPWR VPWR sky130_fd_sc_hd__fill_1
XFILLER_0_172_1251 VPWR VGND VPWR VGND sky130_ef_sc_hd__decap_12
XFILLER_0_133_1213 VPWR VGND VPWR VGND sky130_ef_sc_hd__decap_12
XFILLER_0_172_1295 VPWR VGND VPWR VGND sky130_ef_sc_hd__decap_12
XFILLER_0_34_1343 VGND VGND VPWR VPWR sky130_fd_sc_hd__fill_1
XFILLER_0_213_1281 VGND VGND VPWR VPWR sky130_fd_sc_hd__decap_6
XFILLER_0_133_1279 VPWR VGND VPWR VGND sky130_ef_sc_hd__decap_12
XFILLER_0_7_501 VGND VGND VPWR VPWR sky130_fd_sc_hd__decap_3
XFILLER_0_145_645 VGND VGND VPWR VPWR sky130_fd_sc_hd__fill_1
XFILLER_0_7_545 VPWR VGND VPWR VGND sky130_ef_sc_hd__decap_12
XFILLER_0_7_589 VPWR VGND VPWR VGND sky130_ef_sc_hd__decap_12
XFILLER_0_144_1331 VGND VGND VPWR VPWR sky130_fd_sc_hd__decap_6
XFILLER_0_113_553 VGND VGND VPWR VPWR sky130_fd_sc_hd__decap_6
XFILLER_0_105_1337 VGND VGND VPWR VPWR sky130_fd_sc_hd__decap_6
XFILLER_0_113_597 VPWR VGND VPWR VGND sky130_ef_sc_hd__decap_12
XFILLER_0_41_1303 VGND VGND VPWR VPWR sky130_fd_sc_hd__decap_6
XFILLER_0_220_1241 VPWR VGND VPWR VGND sky130_ef_sc_hd__decap_12
XFILLER_0_140_1239 VPWR VGND VPWR VGND sky130_ef_sc_hd__decap_12
XFILLER_0_220_1285 VPWR VGND VPWR VGND sky130_ef_sc_hd__decap_12
XFILLER_0_78_1281 VGND VGND VPWR VPWR sky130_fd_sc_hd__fill_1
XFILLER_0_223_671 VGND VGND VPWR VPWR sky130_fd_sc_hd__fill_1
XFILLER_0_211_833 VGND VGND VPWR VPWR sky130_fd_sc_hd__decap_6
XFILLER_0_211_877 VPWR VGND VPWR VGND sky130_ef_sc_hd__decap_12
XFILLER_0_210_321 VPWR VGND VPWR VGND sky130_ef_sc_hd__decap_12
XFILLER_0_151_1335 VGND VGND VPWR VPWR sky130_fd_sc_hd__decap_8
XFILLER_0_210_365 VPWR VGND VPWR VGND sky130_ef_sc_hd__decap_12
XPHY_524 VGND VGND VPWR VPWR sky130_fd_sc_hd__decap_3
XPHY_513 VGND VGND VPWR VPWR sky130_fd_sc_hd__decap_3
XPHY_535 VGND VGND VPWR VPWR sky130_fd_sc_hd__decap_3
XPHY_502 VGND VGND VPWR VPWR sky130_fd_sc_hd__decap_3
XPHY_1123 VGND VGND VPWR VPWR sky130_fd_sc_hd__decap_3
XPHY_1112 VGND VGND VPWR VPWR sky130_fd_sc_hd__decap_3
XPHY_1101 VGND VGND VPWR VPWR sky130_fd_sc_hd__decap_3
XPHY_546 VGND VGND VPWR VPWR sky130_fd_sc_hd__decap_3
XFILLER_0_4_1241 VPWR VGND VPWR VGND sky130_ef_sc_hd__decap_12
XPHY_557 VGND VGND VPWR VPWR sky130_fd_sc_hd__decap_3
XPHY_568 VGND VGND VPWR VPWR sky130_fd_sc_hd__decap_3
XPHY_1134 VGND VGND VPWR VPWR sky130_fd_sc_hd__decap_3
XPHY_1156 VGND VGND VPWR VPWR sky130_fd_sc_hd__decap_3
XPHY_1145 VGND VGND VPWR VPWR sky130_fd_sc_hd__decap_3
XPHY_579 VGND VGND VPWR VPWR sky130_fd_sc_hd__decap_3
XFILLER_0_4_1285 VPWR VGND VPWR VGND sky130_ef_sc_hd__decap_12
XPHY_1189 VGND VGND VPWR VPWR sky130_fd_sc_hd__decap_3
XPHY_1178 VGND VGND VPWR VPWR sky130_fd_sc_hd__decap_3
XPHY_1167 VGND VGND VPWR VPWR sky130_fd_sc_hd__decap_3
XFILLER_0_149_1253 VGND VGND VPWR VPWR sky130_fd_sc_hd__fill_1
XFILLER_0_34_643 VPWR VGND VPWR VGND sky130_ef_sc_hd__decap_12
XFILLER_0_46_1225 VGND VGND VPWR VPWR sky130_fd_sc_hd__fill_1
XANTENNA_input53_A psum_col0_in[27] VGND VGND VPWR VPWR sky130_fd_sc_hd__diode_2
XFILLER_0_219_933 VPWR VGND VPWR VGND sky130_ef_sc_hd__decap_12
XFILLER_0_218_421 VPWR VGND VPWR VGND sky130_ef_sc_hd__decap_12
XFILLER_0_219_977 VPWR VGND VPWR VGND sky130_ef_sc_hd__decap_12
XFILLER_0_56_29 VPWR VGND VPWR VGND sky130_ef_sc_hd__decap_12
XFILLER_0_206_605 VPWR VGND VPWR VGND sky130_ef_sc_hd__decap_12
XFILLER_0_156_1213 VPWR VGND VPWR VGND sky130_ef_sc_hd__decap_12
XFILLER_0_92_1201 VPWR VGND VPWR VGND sky130_ef_sc_hd__decap_12
XFILLER_0_57_1343 VGND VGND VPWR VPWR sky130_fd_sc_hd__fill_1
XFILLER_0_214_693 VGND VGND VPWR VPWR sky130_fd_sc_hd__decap_6
XFILLER_0_213_181 VPWR VGND VPWR VGND sky130_ef_sc_hd__decap_12
XTAP_1271 VGND VPWR sky130_fd_sc_hd__tapvpwrvgnd_1
XTAP_1293 VGND VPWR sky130_fd_sc_hd__tapvpwrvgnd_1
XTAP_1282 VGND VPWR sky130_fd_sc_hd__tapvpwrvgnd_1
XTAP_1260 VGND VPWR sky130_fd_sc_hd__tapvpwrvgnd_1
XFILLER_0_127_645 VGND VGND VPWR VPWR sky130_fd_sc_hd__fill_1
XFILLER_0_108_881 VPWR VGND VPWR VGND sky130_ef_sc_hd__decap_12
XFILLER_0_188_27 VGND VGND VPWR VPWR sky130_fd_sc_hd__fill_1
XFILLER_0_128_1337 VGND VGND VPWR VPWR sky130_fd_sc_hd__fill_1
XFILLER_0_107_391 VGND VGND VPWR VPWR sky130_fd_sc_hd__fill_1
XFILLER_0_188_49 VGND VGND VPWR VPWR sky130_fd_sc_hd__fill_1
XFILLER_0_97_47 VGND VGND VPWR VPWR sky130_fd_sc_hd__decap_3
XFILLER_0_204_1225 VGND VGND VPWR VPWR sky130_fd_sc_hd__fill_1
XFILLER_0_110_501 VPWR VGND VPWR VGND sky130_ef_sc_hd__decap_12
XFILLER_0_25_1309 VGND VGND VPWR VPWR sky130_fd_sc_hd__fill_1
XFILLER_0_110_545 VPWR VGND VPWR VGND sky130_ef_sc_hd__decap_12
XFILLER_0_100_1201 VPWR VGND VPWR VGND sky130_ef_sc_hd__decap_12
XFILLER_0_110_589 VPWR VGND VPWR VGND sky130_ef_sc_hd__decap_12
XFILLER_0_224_413 VGND VGND VPWR VPWR sky130_fd_sc_hd__decap_6
XANTENNA_u_pe10_weight_in[7] net146 VGND VGND VPWR VPWR sky130_fd_sc_hd__diode_2
XFILLER_0_224_457 VPWR VGND VPWR VGND sky130_ef_sc_hd__decap_12
XFILLER_0_69_1225 VPWR VGND VPWR VGND sky130_ef_sc_hd__decap_12
XFILLER_0_16_643 VPWR VGND VPWR VGND sky130_ef_sc_hd__decap_12
XFILLER_0_105_317 VPWR VGND VPWR VGND sky130_ef_sc_hd__decap_12
XFILLER_0_109_1281 VGND VGND VPWR VPWR sky130_fd_sc_hd__decap_6
XFILLER_0_105_1101 VPWR VGND VPWR VGND sky130_ef_sc_hd__decap_12
XFILLER_0_113_361 VPWR VGND VPWR VGND sky130_ef_sc_hd__decap_12
XFILLER_0_105_1145 VPWR VGND VPWR VGND sky130_ef_sc_hd__decap_12
XFILLER_0_179_1213 VPWR VGND VPWR VGND sky130_ef_sc_hd__decap_12
XFILLER_0_105_1189 VPWR VGND VPWR VGND sky130_ef_sc_hd__decap_12
XFILLER_0_45_1291 VPWR VGND VPWR VGND sky130_ef_sc_hd__decap_12
XFILLER_0_220_1093 VPWR VGND VPWR VGND sky130_ef_sc_hd__decap_12
XFILLER_0_179_1279 VPWR VGND VPWR VGND sky130_ef_sc_hd__decap_12
XFILLER_0_216_925 VPWR VGND VPWR VGND sky130_ef_sc_hd__decap_12
XFILLER_0_216_1129 VPWR VGND VPWR VGND sky130_ef_sc_hd__decap_12
XFILLER_0_211_641 VPWR VGND VPWR VGND sky130_ef_sc_hd__decap_12
XFILLER_0_211_685 VPWR VGND VPWR VGND sky130_ef_sc_hd__decap_12
XFILLER_0_210_151 VPWR VGND VPWR VGND sky130_ef_sc_hd__decap_12
XFILLER_0_116_1263 VPWR VGND VPWR VGND sky130_ef_sc_hd__decap_12
XFILLER_0_112_1105 VPWR VGND VPWR VGND sky130_ef_sc_hd__decap_12
XPHY_310 VGND VGND VPWR VPWR sky130_fd_sc_hd__decap_3
XFILLER_0_112_1149 VPWR VGND VPWR VGND sky130_ef_sc_hd__decap_12
XPHY_343 VGND VGND VPWR VPWR sky130_fd_sc_hd__decap_3
XFILLER_0_13_1213 VPWR VGND VPWR VGND sky130_ef_sc_hd__decap_12
XFILLER_0_52_1251 VPWR VGND VPWR VGND sky130_ef_sc_hd__decap_12
XPHY_321 VGND VGND VPWR VPWR sky130_fd_sc_hd__decap_3
XPHY_332 VGND VGND VPWR VPWR sky130_fd_sc_hd__decap_3
XFILLER_0_186_1239 VPWR VGND VPWR VGND sky130_ef_sc_hd__decap_12
XFILLER_0_213_55 VGND VGND VPWR VPWR sky130_fd_sc_hd__fill_1
XPHY_376 VGND VGND VPWR VPWR sky130_fd_sc_hd__decap_3
XPHY_365 VGND VGND VPWR VPWR sky130_fd_sc_hd__decap_3
XPHY_354 VGND VGND VPWR VPWR sky130_fd_sc_hd__decap_3
XFILLER_0_52_1295 VPWR VGND VPWR VGND sky130_ef_sc_hd__decap_12
XFILLER_0_87_1303 VGND VGND VPWR VPWR sky130_fd_sc_hd__decap_6
XFILLER_0_108_133 VGND VGND VPWR VPWR sky130_fd_sc_hd__decap_6
XFILLER_0_4_1093 VPWR VGND VPWR VGND sky130_ef_sc_hd__decap_12
XFILLER_0_13_1279 VPWR VGND VPWR VGND sky130_ef_sc_hd__decap_12
XPHY_387 VGND VGND VPWR VPWR sky130_fd_sc_hd__decap_3
XPHY_398 VGND VGND VPWR VPWR sky130_fd_sc_hd__decap_3
XFILLER_0_108_177 VPWR VGND VPWR VGND sky130_ef_sc_hd__decap_12
XFILLER_0_123_1201 VPWR VGND VPWR VGND sky130_ef_sc_hd__decap_12
XFILLER_0_105_895 VGND VGND VPWR VPWR sky130_fd_sc_hd__fill_1
XFILLER_0_1_529 VPWR VGND VPWR VGND sky130_ef_sc_hd__decap_12
XFILLER_0_104_361 VGND VGND VPWR VPWR sky130_fd_sc_hd__decap_3
XFILLER_0_162_1283 VPWR VGND VPWR VGND sky130_ef_sc_hd__decap_12
XFILLER_0_67_39 VGND VGND VPWR VPWR sky130_fd_sc_hd__decap_8
XFILLER_0_219_741 VPWR VGND VPWR VGND sky130_ef_sc_hd__decap_12
XFILLER_0_123_1267 VPWR VGND VPWR VGND sky130_ef_sc_hd__decap_12
XFILLER_0_24_1331 VGND VGND VPWR VPWR sky130_fd_sc_hd__decap_6
XFILLER_0_203_1291 VPWR VGND VPWR VGND sky130_ef_sc_hd__decap_12
XFILLER_0_219_785 VPWR VGND VPWR VGND sky130_ef_sc_hd__decap_12
XFILLER_0_218_251 VGND VGND VPWR VPWR sky130_fd_sc_hd__fill_1
XFILLER_0_158_1319 VPWR VGND VPWR VGND sky130_ef_sc_hd__decap_12
XFILLER_0_94_1307 VPWR VGND VPWR VGND sky130_ef_sc_hd__decap_12
XFILLER_0_20_1239 VPWR VGND VPWR VGND sky130_ef_sc_hd__decap_12
XFILLER_0_174_29 VPWR VGND VPWR VGND sky130_ef_sc_hd__decap_12
XFILLER_0_222_917 VGND VGND VPWR VPWR sky130_fd_sc_hd__decap_6
XFILLER_0_221_405 VPWR VGND VPWR VGND sky130_ef_sc_hd__decap_12
XFILLER_0_83_27 VPWR VGND VPWR VGND sky130_ef_sc_hd__decap_12
XFILLER_0_221_449 VPWR VGND VPWR VGND sky130_ef_sc_hd__decap_12
XFILLER_0_130_1227 VPWR VGND VPWR VGND sky130_ef_sc_hd__decap_12
XFILLER_0_9_629 VPWR VGND VPWR VGND sky130_ef_sc_hd__decap_12
XFILLER_0_31_1335 VGND VGND VPWR VPWR sky130_fd_sc_hd__decap_8
XFILLER_0_210_1273 VPWR VGND VPWR VGND sky130_ef_sc_hd__decap_12
XFILLER_0_199_37 VPWR VGND VPWR VGND sky130_ef_sc_hd__decap_12
XFILLER_0_4_301 VGND VGND VPWR VPWR sky130_fd_sc_hd__decap_6
XFILLER_0_114_125 VPWR VGND VPWR VGND sky130_ef_sc_hd__decap_12
XFILLER_0_4_345 VPWR VGND VPWR VGND sky130_ef_sc_hd__decap_12
XFILLER_0_111_821 VPWR VGND VPWR VGND sky130_ef_sc_hd__decap_12
XFILLER_0_4_389 VPWR VGND VPWR VGND sky130_ef_sc_hd__decap_12
XFILLER_0_29_1253 VGND VGND VPWR VPWR sky130_fd_sc_hd__fill_1
XFILLER_0_114_169 VPWR VGND VPWR VGND sky130_ef_sc_hd__decap_12
XFILLER_0_141_1323 VPWR VGND VPWR VGND sky130_ef_sc_hd__decap_12
XFILLER_0_111_865 VPWR VGND VPWR VGND sky130_ef_sc_hd__decap_12
XFILLER_0_102_1307 VPWR VGND VPWR VGND sky130_ef_sc_hd__decap_12
XFILLER_0_0_573 VGND VGND VPWR VPWR sky130_fd_sc_hd__fill_2
XFILLER_0_0_551 VGND VGND VPWR VPWR sky130_fd_sc_hd__fill_2
XFILLER_0_148_41 VGND VGND VPWR VPWR sky130_fd_sc_hd__decap_8
XFILLER_0_224_221 VPWR VGND VPWR VGND sky130_ef_sc_hd__decap_12
XFILLER_0_225_777 VGND VGND VPWR VPWR sky130_fd_sc_hd__decap_6
XFILLER_0_32_3 VPWR VGND VPWR VGND sky130_ef_sc_hd__decap_12
XTAP_2708 VGND VPWR sky130_fd_sc_hd__tapvpwrvgnd_1
XTAP_2719 VGND VPWR sky130_fd_sc_hd__tapvpwrvgnd_1
XFILLER_0_197_629 VPWR VGND VPWR VGND sky130_ef_sc_hd__decap_12
XFILLER_0_224_265 VPWR VGND VPWR VGND sky130_ef_sc_hd__decap_12
XFILLER_0_95_605 VPWR VGND VPWR VGND sky130_ef_sc_hd__decap_12
XFILLER_0_36_1213 VPWR VGND VPWR VGND sky130_ef_sc_hd__decap_12
XFILLER_0_1_1233 VPWR VGND VPWR VGND sky130_ef_sc_hd__decap_12
XFILLER_0_146_1201 VPWR VGND VPWR VGND sky130_ef_sc_hd__decap_12
XFILLER_0_106_637 VGND VGND VPWR VPWR sky130_fd_sc_hd__decap_6
XFILLER_0_105_125 VPWR VGND VPWR VGND sky130_ef_sc_hd__decap_12
XFILLER_0_121_629 VPWR VGND VPWR VGND sky130_ef_sc_hd__decap_12
XFILLER_0_105_169 VPWR VGND VPWR VGND sky130_ef_sc_hd__decap_12
XANTENNA_input155_A w11[15] VGND VGND VPWR VPWR sky130_fd_sc_hd__diode_2
Xinput101 w00[0] VGND VGND VPWR VPWR net101 sky130_fd_sc_hd__buf_1
Xinput134 w10[10] VGND VGND VPWR VPWR net134 sky130_fd_sc_hd__clkbuf_4
Xinput145 w10[6] VGND VGND VPWR VPWR net145 sky130_fd_sc_hd__clkbuf_4
Xinput123 w01[15] VGND VGND VPWR VPWR net123 sky130_fd_sc_hd__clkbuf_4
Xinput112 w00[5] VGND VGND VPWR VPWR net112 sky130_fd_sc_hd__buf_1
XFILLER_0_216_755 VGND VGND VPWR VPWR sky130_fd_sc_hd__fill_1
Xinput156 w11[1] VGND VGND VPWR VPWR net156 sky130_fd_sc_hd__buf_4
XANTENNA_input16_A act_row0_in[9] VGND VGND VPWR VPWR sky130_fd_sc_hd__diode_2
XFILLER_0_153_1249 VGND VGND VPWR VPWR sky130_fd_sc_hd__decap_4
XFILLER_0_86_605 VPWR VGND VPWR VGND sky130_ef_sc_hd__decap_12
XFILLER_0_212_961 VPWR VGND VPWR VGND sky130_ef_sc_hd__decap_12
XANTENNA_u_pe00_act_in[15] net7 VGND VGND VPWR VPWR sky130_fd_sc_hd__diode_2
XFILLER_0_224_65 VPWR VGND VPWR VGND sky130_ef_sc_hd__decap_12
XPHY_151 VGND VGND VPWR VPWR sky130_fd_sc_hd__decap_3
XPHY_140 VGND VGND VPWR VPWR sky130_fd_sc_hd__decap_3
XPHY_184 VGND VGND VPWR VPWR sky130_fd_sc_hd__decap_3
XPHY_173 VGND VGND VPWR VPWR sky130_fd_sc_hd__decap_3
XPHY_162 VGND VGND VPWR VPWR sky130_fd_sc_hd__decap_3
XFILLER_0_109_497 VGND VGND VPWR VPWR sky130_fd_sc_hd__decap_6
XPHY_195 VGND VGND VPWR VPWR sky130_fd_sc_hd__decap_3
XFILLER_0_2_805 VGND VGND VPWR VPWR sky130_fd_sc_hd__decap_6
XFILLER_0_2_849 VPWR VGND VPWR VGND sky130_ef_sc_hd__decap_12
XFILLER_0_78_49 VGND VGND VPWR VPWR sky130_fd_sc_hd__fill_1
XFILLER_0_78_27 VGND VGND VPWR VPWR sky130_fd_sc_hd__fill_1
XFILLER_0_1_337 VPWR VGND VPWR VGND sky130_ef_sc_hd__decap_12
XFILLER_0_10_605 VPWR VGND VPWR VGND sky130_ef_sc_hd__decap_12
XFILLER_0_98_1251 VPWR VGND VPWR VGND sky130_ef_sc_hd__decap_12
XFILLER_0_59_1213 VPWR VGND VPWR VGND sky130_ef_sc_hd__decap_12
XFILLER_0_98_1295 VPWR VGND VPWR VGND sky130_ef_sc_hd__decap_12
XFILLER_0_222_725 VPWR VGND VPWR VGND sky130_ef_sc_hd__decap_12
XFILLER_0_179_629 VPWR VGND VPWR VGND sky130_ef_sc_hd__decap_12
XFILLER_0_59_1279 VPWR VGND VPWR VGND sky130_ef_sc_hd__decap_12
XFILLER_0_222_769 VPWR VGND VPWR VGND sky130_ef_sc_hd__decap_12
XFILLER_0_77_605 VPWR VGND VPWR VGND sky130_ef_sc_hd__decap_12
XFILLER_0_221_279 VGND VGND VPWR VPWR sky130_fd_sc_hd__fill_1
XFILLER_0_169_1201 VPWR VGND VPWR VGND sky130_ef_sc_hd__decap_12
XFILLER_0_92_619 VPWR VGND VPWR VGND sky130_ef_sc_hd__decap_12
XFILLER_0_169_1267 VPWR VGND VPWR VGND sky130_ef_sc_hd__decap_12
XFILLER_0_5_665 VGND VGND VPWR VPWR sky130_fd_sc_hd__decap_6
XFILLER_0_66_1239 VPWR VGND VPWR VGND sky130_ef_sc_hd__decap_12
XFILLER_0_103_629 VPWR VGND VPWR VGND sky130_ef_sc_hd__decap_12
XFILLER_0_4_153 VPWR VGND VPWR VGND sky130_ef_sc_hd__decap_12
XFILLER_0_7_41 VPWR VGND VPWR VGND sky130_ef_sc_hd__decap_12
XFILLER_0_4_197 VPWR VGND VPWR VGND sky130_ef_sc_hd__decap_12
XFILLER_0_111_673 VPWR VGND VPWR VGND sky130_ef_sc_hd__decap_12
XFILLER_0_7_85 VPWR VGND VPWR VGND sky130_ef_sc_hd__decap_12
XFILLER_0_106_1273 VPWR VGND VPWR VGND sky130_ef_sc_hd__decap_12
XFILLER_0_176_1227 VPWR VGND VPWR VGND sky130_ef_sc_hd__decap_12
XANTENNA_input8_A act_row0_in[1] VGND VGND VPWR VPWR sky130_fd_sc_hd__diode_2
XFILLER_0_42_1283 VPWR VGND VPWR VGND sky130_ef_sc_hd__decap_12
XFILLER_0_225_541 VPWR VGND VPWR VGND sky130_ef_sc_hd__decap_12
XFILLER_0_77_1335 VGND VGND VPWR VPWR sky130_fd_sc_hd__fill_1
XFILLER_0_217_1213 VPWR VGND VPWR VGND sky130_ef_sc_hd__decap_12
XFILLER_0_225_585 VPWR VGND VPWR VGND sky130_ef_sc_hd__decap_12
XFILLER_0_38_1319 VPWR VGND VPWR VGND sky130_ef_sc_hd__decap_12
XFILLER_0_217_1257 VPWR VGND VPWR VGND sky130_ef_sc_hd__decap_12
XTAP_2516 VGND VPWR sky130_fd_sc_hd__tapvpwrvgnd_1
XTAP_2527 VGND VPWR sky130_fd_sc_hd__tapvpwrvgnd_1
XTAP_2505 VGND VPWR sky130_fd_sc_hd__tapvpwrvgnd_1
XFILLER_0_68_605 VPWR VGND VPWR VGND sky130_ef_sc_hd__decap_12
XTAP_2549 VGND VPWR sky130_fd_sc_hd__tapvpwrvgnd_1
XTAP_2538 VGND VPWR sky130_fd_sc_hd__tapvpwrvgnd_1
XTAP_1815 VGND VPWR sky130_fd_sc_hd__tapvpwrvgnd_1
XTAP_1804 VGND VPWR sky130_fd_sc_hd__tapvpwrvgnd_1
XFILLER_0_113_1233 VPWR VGND VPWR VGND sky130_ef_sc_hd__decap_12
XTAP_1826 VGND VPWR sky130_fd_sc_hd__tapvpwrvgnd_1
XTAP_1837 VGND VPWR sky130_fd_sc_hd__tapvpwrvgnd_1
XTAP_1848 VGND VPWR sky130_fd_sc_hd__tapvpwrvgnd_1
XFILLER_0_187_1323 VPWR VGND VPWR VGND sky130_ef_sc_hd__decap_12
XTAP_1859 VGND VPWR sky130_fd_sc_hd__tapvpwrvgnd_1
XFILLER_0_148_1307 VPWR VGND VPWR VGND sky130_ef_sc_hd__decap_12
XFILLER_0_91_641 VGND VGND VPWR VPWR sky130_fd_sc_hd__decap_4
XFILLER_0_10_1227 VPWR VGND VPWR VGND sky130_ef_sc_hd__decap_12
XFILLER_0_106_401 VPWR VGND VPWR VGND sky130_ef_sc_hd__decap_12
XFILLER_0_1_1063 VGND VGND VPWR VPWR sky130_fd_sc_hd__fill_1
XFILLER_0_84_1339 VGND VGND VPWR VPWR sky130_fd_sc_hd__decap_4
XFILLER_0_106_445 VPWR VGND VPWR VGND sky130_ef_sc_hd__decap_12
XFILLER_0_224_1217 VPWR VGND VPWR VGND sky130_ef_sc_hd__decap_12
XFILLER_0_106_489 VPWR VGND VPWR VGND sky130_ef_sc_hd__decap_12
XFILLER_0_21_1323 VPWR VGND VPWR VGND sky130_ef_sc_hd__decap_12
XFILLER_0_200_1283 VPWR VGND VPWR VGND sky130_ef_sc_hd__decap_12
XFILLER_0_64_29 VPWR VGND VPWR VGND sky130_ef_sc_hd__decap_12
XFILLER_0_59_605 VPWR VGND VPWR VGND sky130_ef_sc_hd__decap_12
XFILLER_0_8_1239 VPWR VGND VPWR VGND sky130_ef_sc_hd__decap_12
XFILLER_0_131_1311 VPWR VGND VPWR VGND sky130_ef_sc_hd__decap_12
XANTENNA_u_pe10_act_in[14] net22 VGND VGND VPWR VPWR sky130_fd_sc_hd__diode_2
XFILLER_0_184_643 VPWR VGND VPWR VGND sky130_ef_sc_hd__decap_12
XFILLER_0_74_619 VPWR VGND VPWR VGND sky130_ef_sc_hd__decap_12
XFILLER_0_104_57 VPWR VGND VPWR VGND sky130_ef_sc_hd__decap_12
XFILLER_0_89_15 VPWR VGND VPWR VGND sky130_ef_sc_hd__decap_12
XFILLER_0_109_261 VPWR VGND VPWR VGND sky130_ef_sc_hd__decap_12
XFILLER_0_2_613 VPWR VGND VPWR VGND sky130_ef_sc_hd__decap_12
XFILLER_0_2_657 VPWR VGND VPWR VGND sky130_ef_sc_hd__decap_12
XFILLER_0_26_1201 VPWR VGND VPWR VGND sky130_ef_sc_hd__decap_12
XFILLER_0_196_49 VGND VGND VPWR VPWR sky130_fd_sc_hd__fill_1
XFILLER_0_1_167 VGND VGND VPWR VPWR sky130_fd_sc_hd__fill_1
XFILLER_0_50_593 VPWR VGND VPWR VGND sky130_ef_sc_hd__decap_12
XFILLER_0_199_1249 VGND VGND VPWR VPWR sky130_fd_sc_hd__decap_4
XFILLER_0_129_10 VPWR VGND VPWR VGND sky130_ef_sc_hd__decap_12
XFILLER_0_38_41 VGND VGND VPWR VPWR sky130_fd_sc_hd__decap_8
XFILLER_0_226_349 VGND VGND VPWR VPWR sky130_fd_sc_hd__decap_4
XFILLER_0_222_533 VPWR VGND VPWR VGND sky130_ef_sc_hd__decap_12
XPHY_909 VGND VGND VPWR VPWR sky130_fd_sc_hd__decap_3
XFILLER_0_33_1249 VGND VGND VPWR VPWR sky130_fd_sc_hd__decap_4
XFILLER_0_73_641 VGND VGND VPWR VPWR sky130_fd_sc_hd__decap_4
XFILLER_0_5_473 VPWR VGND VPWR VGND sky130_ef_sc_hd__decap_12
XFILLER_0_182_1275 VGND VGND VPWR VPWR sky130_fd_sc_hd__decap_6
XFILLER_0_143_1237 VPWR VGND VPWR VGND sky130_ef_sc_hd__decap_12
XFILLER_0_104_949 VGND VGND VPWR VPWR sky130_fd_sc_hd__decap_3
XFILLER_0_41_593 VPWR VGND VPWR VGND sky130_ef_sc_hd__decap_12
XFILLER_0_217_305 VPWR VGND VPWR VGND sky130_ef_sc_hd__decap_12
XFILLER_0_112_993 VPWR VGND VPWR VGND sky130_ef_sc_hd__decap_12
XFILLER_0_217_349 VPWR VGND VPWR VGND sky130_ef_sc_hd__decap_12
XFILLER_0_226_894 VGND VGND VPWR VPWR sky130_fd_sc_hd__fill_2
XFILLER_0_217_1021 VPWR VGND VPWR VGND sky130_ef_sc_hd__decap_12
XFILLER_0_225_393 VPWR VGND VPWR VGND sky130_ef_sc_hd__decap_12
XTAP_2302 VGND VPWR sky130_fd_sc_hd__tapvpwrvgnd_1
XFILLER_0_217_1065 VPWR VGND VPWR VGND sky130_ef_sc_hd__decap_12
XTAP_2335 VGND VPWR sky130_fd_sc_hd__tapvpwrvgnd_1
XTAP_2324 VGND VPWR sky130_fd_sc_hd__tapvpwrvgnd_1
XTAP_2313 VGND VPWR sky130_fd_sc_hd__tapvpwrvgnd_1
XTAP_2368 VGND VPWR sky130_fd_sc_hd__tapvpwrvgnd_1
XTAP_2357 VGND VPWR sky130_fd_sc_hd__tapvpwrvgnd_1
XANTENNA_input118_A w01[10] VGND VGND VPWR VPWR sky130_fd_sc_hd__diode_2
XFILLER_0_90_1343 VGND VGND VPWR VPWR sky130_fd_sc_hd__fill_1
XTAP_2346 VGND VPWR sky130_fd_sc_hd__tapvpwrvgnd_1
XTAP_1601 VGND VPWR sky130_fd_sc_hd__tapvpwrvgnd_1
XTAP_1612 VGND VPWR sky130_fd_sc_hd__tapvpwrvgnd_1
XTAP_1623 VGND VPWR sky130_fd_sc_hd__tapvpwrvgnd_1
XTAP_2379 VGND VPWR sky130_fd_sc_hd__tapvpwrvgnd_1
XFILLER_0_166_643 VPWR VGND VPWR VGND sky130_ef_sc_hd__decap_12
XTAP_1645 VGND VPWR sky130_fd_sc_hd__tapvpwrvgnd_1
XTAP_1634 VGND VPWR sky130_fd_sc_hd__tapvpwrvgnd_1
XFILLER_0_56_619 VPWR VGND VPWR VGND sky130_ef_sc_hd__decap_12
XFILLER_0_7_1261 VPWR VGND VPWR VGND sky130_ef_sc_hd__decap_12
XTAP_1656 VGND VPWR sky130_fd_sc_hd__tapvpwrvgnd_1
XTAP_1667 VGND VPWR sky130_fd_sc_hd__tapvpwrvgnd_1
XFILLER_0_113_1063 VGND VGND VPWR VPWR sky130_fd_sc_hd__fill_1
XTAP_1678 VGND VPWR sky130_fd_sc_hd__tapvpwrvgnd_1
XTAP_1689 VGND VPWR sky130_fd_sc_hd__tapvpwrvgnd_1
XFILLER_0_107_721 VGND VGND VPWR VPWR sky130_fd_sc_hd__decap_6
XFILLER_0_3_1169 VGND VGND VPWR VPWR sky130_fd_sc_hd__decap_6
XANTENNA_input83_A psum_col1_in[25] VGND VGND VPWR VPWR sky130_fd_sc_hd__diode_2
XFILLER_0_221_55 VGND VGND VPWR VPWR sky130_fd_sc_hd__fill_1
XFILLER_0_88_1283 VPWR VGND VPWR VGND sky130_ef_sc_hd__decap_12
XFILLER_0_107_765 VPWR VGND VPWR VGND sky130_ef_sc_hd__decap_12
XFILLER_0_49_1201 VPWR VGND VPWR VGND sky130_ef_sc_hd__decap_12
XFILLER_0_49_1267 VPWR VGND VPWR VGND sky130_ef_sc_hd__decap_12
XFILLER_0_106_253 VPWR VGND VPWR VGND sky130_ef_sc_hd__decap_12
XFILLER_0_32_593 VPWR VGND VPWR VGND sky130_ef_sc_hd__decap_12
XFILLER_0_75_39 VGND VGND VPWR VPWR sky130_fd_sc_hd__decap_8
XFILLER_0_159_1255 VPWR VGND VPWR VGND sky130_ef_sc_hd__decap_12
XFILLER_0_56_1227 VPWR VGND VPWR VGND sky130_ef_sc_hd__decap_12
XFILLER_0_182_29 VPWR VGND VPWR VGND sky130_ef_sc_hd__decap_12
XFILLER_0_99_593 VPWR VGND VPWR VGND sky130_ef_sc_hd__decap_12
XTAP_2891 VGND VPWR sky130_fd_sc_hd__tapvpwrvgnd_1
XTAP_2880 VGND VPWR sky130_fd_sc_hd__tapvpwrvgnd_1
XFILLER_0_138_3 VPWR VGND VPWR VGND sky130_ef_sc_hd__decap_12
XFILLER_0_55_641 VGND VGND VPWR VPWR sky130_fd_sc_hd__decap_4
XFILLER_0_67_1323 VPWR VGND VPWR VGND sky130_ef_sc_hd__decap_12
XFILLER_0_207_1201 VPWR VGND VPWR VGND sky130_ef_sc_hd__decap_12
XFILLER_0_70_655 VGND VGND VPWR VPWR sky130_fd_sc_hd__decap_4
XFILLER_0_28_1307 VPWR VGND VPWR VGND sky130_ef_sc_hd__decap_12
XFILLER_0_3_933 VPWR VGND VPWR VGND sky130_ef_sc_hd__decap_12
XFILLER_0_2_421 VPWR VGND VPWR VGND sky130_ef_sc_hd__decap_12
XFILLER_0_207_1267 VPWR VGND VPWR VGND sky130_ef_sc_hd__decap_12
Xoutput224 net224 VGND VGND VPWR VPWR psum_col1_out[5] sky130_fd_sc_hd__clkbuf_4
XFILLER_0_3_977 VPWR VGND VPWR VGND sky130_ef_sc_hd__decap_12
XFILLER_0_23_593 VPWR VGND VPWR VGND sky130_ef_sc_hd__decap_12
Xoutput202 net202 VGND VGND VPWR VPWR psum_col1_out[14] sky130_fd_sc_hd__clkbuf_4
Xoutput213 net213 VGND VGND VPWR VPWR psum_col1_out[24] sky130_fd_sc_hd__clkbuf_4
XFILLER_0_112_245 VGND VGND VPWR VPWR sky130_fd_sc_hd__decap_6
XFILLER_0_112_289 VPWR VGND VPWR VGND sky130_ef_sc_hd__decap_12
XFILLER_0_142_1281 VGND VGND VPWR VPWR sky130_fd_sc_hd__fill_1
XFILLER_0_177_1311 VPWR VGND VPWR VGND sky130_ef_sc_hd__decap_12
XFILLER_0_215_809 VPWR VGND VPWR VGND sky130_ef_sc_hd__decap_12
XFILLER_0_4_53 VPWR VGND VPWR VGND sky130_ef_sc_hd__decap_12
XFILLER_0_156_41 VGND VGND VPWR VPWR sky130_fd_sc_hd__decap_8
XFILLER_0_218_1341 VGND VGND VPWR VPWR sky130_fd_sc_hd__decap_3
XFILLER_0_223_853 VPWR VGND VPWR VGND sky130_ef_sc_hd__decap_12
XFILLER_0_138_1339 VGND VGND VPWR VPWR sky130_fd_sc_hd__decap_4
XFILLER_0_4_97 VPWR VGND VPWR VGND sky130_ef_sc_hd__decap_12
XFILLER_0_214_1205 VPWR VGND VPWR VGND sky130_ef_sc_hd__decap_12
XFILLER_0_222_363 VGND VGND VPWR VPWR sky130_fd_sc_hd__fill_1
XFILLER_0_223_897 VPWR VGND VPWR VGND sky130_ef_sc_hd__decap_12
XFILLER_0_148_643 VPWR VGND VPWR VGND sky130_ef_sc_hd__decap_12
XPHY_706 VGND VGND VPWR VPWR sky130_fd_sc_hd__decap_3
XFILLER_0_38_619 VPWR VGND VPWR VGND sky130_ef_sc_hd__decap_12
XPHY_717 VGND VGND VPWR VPWR sky130_fd_sc_hd__decap_3
XPHY_739 VGND VGND VPWR VPWR sky130_fd_sc_hd__decap_3
XFILLER_0_110_1203 VGND VGND VPWR VPWR sky130_fd_sc_hd__fill_1
XPHY_728 VGND VGND VPWR VPWR sky130_fd_sc_hd__decap_3
XFILLER_0_11_1311 VPWR VGND VPWR VGND sky130_ef_sc_hd__decap_12
XFILLER_0_184_1337 VGND VGND VPWR VPWR sky130_fd_sc_hd__fill_1
XFILLER_0_225_1301 VPWR VGND VPWR VGND sky130_ef_sc_hd__decap_12
XFILLER_0_104_713 VPWR VGND VPWR VGND sky130_ef_sc_hd__decap_12
XFILLER_0_61_655 VGND VGND VPWR VPWR sky130_fd_sc_hd__fill_2
XFILLER_0_104_757 VPWR VGND VPWR VGND sky130_ef_sc_hd__decap_12
XFILLER_0_5_281 VPWR VGND VPWR VGND sky130_ef_sc_hd__decap_12
XFILLER_0_6_793 VPWR VGND VPWR VGND sky130_ef_sc_hd__decap_12
XFILLER_0_81_1309 VGND VGND VPWR VPWR sky130_fd_sc_hd__fill_1
XFILLER_0_14_593 VPWR VGND VPWR VGND sky130_ef_sc_hd__decap_12
XFILLER_0_218_625 VPWR VGND VPWR VGND sky130_ef_sc_hd__decap_12
XFILLER_0_217_113 VPWR VGND VPWR VGND sky130_ef_sc_hd__decap_12
XFILLER_0_121_1343 VGND VGND VPWR VPWR sky130_fd_sc_hd__fill_1
XFILLER_0_218_669 VPWR VGND VPWR VGND sky130_ef_sc_hd__decap_12
XFILLER_0_79_1249 VGND VGND VPWR VPWR sky130_fd_sc_hd__decap_4
XFILLER_0_9_1323 VPWR VGND VPWR VGND sky130_ef_sc_hd__decap_12
XTAP_2110 VGND VPWR sky130_fd_sc_hd__tapvpwrvgnd_1
XFILLER_0_216_77 VGND VGND VPWR VPWR sky130_fd_sc_hd__decap_6
XFILLER_0_213_385 VGND VGND VPWR VPWR sky130_fd_sc_hd__decap_6
XTAP_2143 VGND VPWR sky130_fd_sc_hd__tapvpwrvgnd_1
XTAP_2132 VGND VPWR sky130_fd_sc_hd__tapvpwrvgnd_1
XTAP_2121 VGND VPWR sky130_fd_sc_hd__tapvpwrvgnd_1
XTAP_2176 VGND VPWR sky130_fd_sc_hd__tapvpwrvgnd_1
XTAP_2165 VGND VPWR sky130_fd_sc_hd__tapvpwrvgnd_1
XTAP_2154 VGND VPWR sky130_fd_sc_hd__tapvpwrvgnd_1
XTAP_1420 VGND VPWR sky130_fd_sc_hd__tapvpwrvgnd_1
XTAP_1431 VGND VPWR sky130_fd_sc_hd__tapvpwrvgnd_1
XTAP_1442 VGND VPWR sky130_fd_sc_hd__tapvpwrvgnd_1
XFILLER_0_189_1237 VPWR VGND VPWR VGND sky130_ef_sc_hd__decap_12
XTAP_2187 VGND VPWR sky130_fd_sc_hd__tapvpwrvgnd_1
XTAP_2198 VGND VPWR sky130_fd_sc_hd__tapvpwrvgnd_1
XTAP_1453 VGND VPWR sky130_fd_sc_hd__tapvpwrvgnd_1
XTAP_1464 VGND VPWR sky130_fd_sc_hd__tapvpwrvgnd_1
XTAP_1475 VGND VPWR sky130_fd_sc_hd__tapvpwrvgnd_1
XTAP_1486 VGND VPWR sky130_fd_sc_hd__tapvpwrvgnd_1
XFILLER_0_37_641 VGND VGND VPWR VPWR sky130_fd_sc_hd__decap_4
XTAP_1497 VGND VPWR sky130_fd_sc_hd__tapvpwrvgnd_1
XFILLER_0_107_573 VPWR VGND VPWR VGND sky130_ef_sc_hd__decap_12
XFILLER_0_52_655 VGND VGND VPWR VPWR sky130_fd_sc_hd__decap_4
XFILLER_0_110_749 VGND VGND VPWR VPWR sky130_fd_sc_hd__decap_6
XFILLER_0_0_925 VGND VGND VPWR VPWR sky130_fd_sc_hd__fill_2
XFILLER_0_86_27 VGND VGND VPWR VPWR sky130_fd_sc_hd__fill_1
XFILLER_0_86_49 VGND VGND VPWR VPWR sky130_fd_sc_hd__fill_1
XFILLER_0_23_1237 VPWR VGND VPWR VGND sky130_ef_sc_hd__decap_12
XFILLER_0_62_1275 VGND VGND VPWR VPWR sky130_fd_sc_hd__decap_6
XFILLER_0_209_647 VPWR VGND VPWR VGND sky130_ef_sc_hd__decap_12
XFILLER_0_223_105 VGND VGND VPWR VPWR sky130_fd_sc_hd__decap_6
XFILLER_0_193_39 VGND VGND VPWR VPWR sky130_fd_sc_hd__decap_8
XFILLER_0_126_22 VGND VGND VPWR VPWR sky130_fd_sc_hd__decap_6
XFILLER_0_223_149 VPWR VGND VPWR VGND sky130_ef_sc_hd__decap_12
XFILLER_0_172_1263 VPWR VGND VPWR VGND sky130_ef_sc_hd__decap_12
XFILLER_0_133_1225 VPWR VGND VPWR VGND sky130_ef_sc_hd__decap_12
XFILLER_0_220_867 VGND VGND VPWR VPWR sky130_fd_sc_hd__fill_1
XFILLER_0_7_557 VGND VGND VPWR VPWR sky130_fd_sc_hd__decap_3
XFILLER_0_160_605 VPWR VGND VPWR VGND sky130_ef_sc_hd__decap_12
XFILLER_0_43_655 VGND VGND VPWR VPWR sky130_fd_sc_hd__fill_2
XFILLER_0_144_1343 VGND VGND VPWR VPWR sky130_fd_sc_hd__fill_1
XFILLER_0_3_741 VPWR VGND VPWR VGND sky130_ef_sc_hd__decap_12
XFILLER_0_3_785 VPWR VGND VPWR VGND sky130_ef_sc_hd__decap_12
XFILLER_0_62_3 VPWR VGND VPWR VGND sky130_ef_sc_hd__decap_12
XFILLER_0_2_251 VGND VGND VPWR VPWR sky130_fd_sc_hd__fill_1
XFILLER_0_80_1331 VGND VGND VPWR VPWR sky130_fd_sc_hd__decap_6
XFILLER_0_220_1253 VGND VGND VPWR VPWR sky130_fd_sc_hd__decap_6
XFILLER_0_220_1297 VPWR VGND VPWR VGND sky130_ef_sc_hd__decap_12
XFILLER_0_215_617 VPWR VGND VPWR VGND sky130_ef_sc_hd__decap_12
XFILLER_0_39_1255 VPWR VGND VPWR VGND sky130_ef_sc_hd__decap_12
XFILLER_0_151_1303 VGND VGND VPWR VPWR sky130_fd_sc_hd__decap_6
XFILLER_0_214_1035 VGND VGND VPWR VPWR sky130_fd_sc_hd__fill_1
XFILLER_0_210_333 VGND VGND VPWR VPWR sky130_fd_sc_hd__decap_3
XFILLER_0_211_889 VGND VGND VPWR VPWR sky130_fd_sc_hd__decap_6
XFILLER_0_210_377 VPWR VGND VPWR VGND sky130_ef_sc_hd__decap_12
XFILLER_0_112_1309 VGND VGND VPWR VPWR sky130_fd_sc_hd__decap_6
XPHY_525 VGND VGND VPWR VPWR sky130_fd_sc_hd__decap_3
XPHY_503 VGND VGND VPWR VPWR sky130_fd_sc_hd__decap_3
XPHY_514 VGND VGND VPWR VPWR sky130_fd_sc_hd__decap_3
XPHY_1102 VGND VGND VPWR VPWR sky130_fd_sc_hd__decap_3
XPHY_1113 VGND VGND VPWR VPWR sky130_fd_sc_hd__decap_3
XPHY_536 VGND VGND VPWR VPWR sky130_fd_sc_hd__decap_3
XPHY_558 VGND VGND VPWR VPWR sky130_fd_sc_hd__decap_3
XPHY_547 VGND VGND VPWR VPWR sky130_fd_sc_hd__decap_3
XFILLER_0_19_641 VGND VGND VPWR VPWR sky130_fd_sc_hd__decap_4
XFILLER_0_4_1253 VGND VGND VPWR VPWR sky130_fd_sc_hd__decap_6
XPHY_569 VGND VGND VPWR VPWR sky130_fd_sc_hd__decap_3
XPHY_1146 VGND VGND VPWR VPWR sky130_fd_sc_hd__decap_3
XPHY_1135 VGND VGND VPWR VPWR sky130_fd_sc_hd__decap_3
XFILLER_0_188_1281 VGND VGND VPWR VPWR sky130_fd_sc_hd__fill_1
XPHY_1157 VGND VGND VPWR VPWR sky130_fd_sc_hd__decap_3
XPHY_1124 VGND VGND VPWR VPWR sky130_fd_sc_hd__decap_3
XFILLER_0_0_1117 VGND VGND VPWR VPWR sky130_fd_sc_hd__decap_3
XPHY_1168 VGND VGND VPWR VPWR sky130_fd_sc_hd__decap_3
XPHY_1179 VGND VGND VPWR VPWR sky130_fd_sc_hd__decap_3
XFILLER_0_151_605 VPWR VGND VPWR VGND sky130_ef_sc_hd__decap_12
XFILLER_0_4_1297 VPWR VGND VPWR VGND sky130_ef_sc_hd__decap_12
XFILLER_0_34_655 VGND VGND VPWR VPWR sky130_fd_sc_hd__decap_4
XFILLER_0_85_1253 VGND VGND VPWR VPWR sky130_fd_sc_hd__fill_1
XFILLER_0_225_1175 VGND VGND VPWR VPWR sky130_fd_sc_hd__fill_1
XFILLER_0_219_945 VGND VGND VPWR VPWR sky130_fd_sc_hd__decap_6
XANTENNA_input46_A psum_col0_in[20] VGND VGND VPWR VPWR sky130_fd_sc_hd__diode_2
XFILLER_0_218_433 VPWR VGND VPWR VGND sky130_ef_sc_hd__decap_12
XFILLER_0_219_989 VPWR VGND VPWR VGND sky130_ef_sc_hd__decap_12
XFILLER_0_206_617 VGND VGND VPWR VPWR sky130_fd_sc_hd__fill_1
XFILLER_0_218_477 VPWR VGND VPWR VGND sky130_ef_sc_hd__decap_12
XFILLER_0_156_1225 VGND VGND VPWR VPWR sky130_fd_sc_hd__fill_1
XFILLER_0_22_1281 VGND VGND VPWR VPWR sky130_fd_sc_hd__fill_1
XFILLER_0_57_1311 VPWR VGND VPWR VGND sky130_ef_sc_hd__decap_12
XFILLER_0_221_609 VGND VGND VPWR VPWR sky130_fd_sc_hd__decap_6
XFILLER_0_92_1213 VPWR VGND VPWR VGND sky130_ef_sc_hd__decap_12
XFILLER_0_72_29 VPWR VGND VPWR VGND sky130_ef_sc_hd__decap_12
XFILLER_0_213_193 VPWR VGND VPWR VGND sky130_ef_sc_hd__decap_12
XFILLER_0_18_1339 VGND VGND VPWR VPWR sky130_fd_sc_hd__decap_4
XTAP_1250 VGND VPWR sky130_fd_sc_hd__tapvpwrvgnd_1
XTAP_1272 VGND VPWR sky130_fd_sc_hd__tapvpwrvgnd_1
XTAP_1283 VGND VPWR sky130_fd_sc_hd__tapvpwrvgnd_1
XTAP_1261 VGND VPWR sky130_fd_sc_hd__tapvpwrvgnd_1
XTAP_1294 VGND VPWR sky130_fd_sc_hd__tapvpwrvgnd_1
XFILLER_0_122_6 VGND VGND VPWR VPWR sky130_fd_sc_hd__fill_2
XFILLER_0_142_605 VPWR VGND VPWR VGND sky130_ef_sc_hd__decap_12
XFILLER_0_108_893 VPWR VGND VPWR VGND sky130_ef_sc_hd__decap_12
XFILLER_0_25_655 VGND VGND VPWR VPWR sky130_fd_sc_hd__fill_2
XFILLER_0_64_1337 VGND VGND VPWR VPWR sky130_fd_sc_hd__fill_1
XFILLER_0_97_15 VPWR VGND VPWR VGND sky130_ef_sc_hd__decap_12
XFILLER_0_110_513 VPWR VGND VPWR VGND sky130_ef_sc_hd__decap_12
XFILLER_0_110_557 VPWR VGND VPWR VGND sky130_ef_sc_hd__decap_12
XFILLER_0_0_755 VGND VGND VPWR VPWR sky130_fd_sc_hd__fill_1
XFILLER_0_100_1213 VPWR VGND VPWR VGND sky130_ef_sc_hd__decap_12
XFILLER_0_46_41 VGND VGND VPWR VPWR sky130_fd_sc_hd__decap_8
XANTENNA_u_pe10_weight_in[6] net145 VGND VGND VPWR VPWR sky130_fd_sc_hd__diode_2
XFILLER_0_224_469 VGND VGND VPWR VPWR sky130_fd_sc_hd__decap_6
XFILLER_0_135_1309 VGND VGND VPWR VPWR sky130_fd_sc_hd__fill_1
XFILLER_0_7_321 VPWR VGND VPWR VGND sky130_ef_sc_hd__decap_12
XFILLER_0_133_605 VPWR VGND VPWR VGND sky130_ef_sc_hd__decap_12
XFILLER_0_69_1237 VPWR VGND VPWR VGND sky130_ef_sc_hd__decap_12
XFILLER_0_16_655 VGND VGND VPWR VPWR sky130_fd_sc_hd__decap_4
XFILLER_0_105_329 VGND VGND VPWR VPWR sky130_fd_sc_hd__decap_6
XFILLER_0_114_841 VPWR VGND VPWR VGND sky130_ef_sc_hd__decap_12
XFILLER_0_222_1315 VGND VGND VPWR VPWR sky130_fd_sc_hd__fill_1
XFILLER_0_105_1113 VGND VGND VPWR VPWR sky130_fd_sc_hd__decap_6
XFILLER_0_31_647 VGND VGND VPWR VPWR sky130_fd_sc_hd__decap_8
XFILLER_0_113_373 VPWR VGND VPWR VGND sky130_ef_sc_hd__decap_12
XFILLER_0_179_1225 VPWR VGND VPWR VGND sky130_ef_sc_hd__decap_12
XFILLER_0_105_1157 VPWR VGND VPWR VGND sky130_ef_sc_hd__decap_12
XFILLER_0_220_1061 VPWR VGND VPWR VGND sky130_ef_sc_hd__decap_12
XFILLER_0_216_937 VPWR VGND VPWR VGND sky130_ef_sc_hd__decap_12
XFILLER_0_215_447 VGND VGND VPWR VPWR sky130_fd_sc_hd__fill_1
XFILLER_0_224_981 VPWR VGND VPWR VGND sky130_ef_sc_hd__decap_12
XFILLER_0_211_653 VPWR VGND VPWR VGND sky130_ef_sc_hd__decap_12
XFILLER_0_155_1291 VPWR VGND VPWR VGND sky130_ef_sc_hd__decap_12
XFILLER_0_210_141 VGND VGND VPWR VPWR sky130_fd_sc_hd__decap_8
XFILLER_0_116_1275 VGND VGND VPWR VPWR sky130_fd_sc_hd__decap_6
XANTENNA_input100_A valid_row1_in VGND VGND VPWR VPWR sky130_fd_sc_hd__diode_2
XPHY_300 VGND VGND VPWR VPWR sky130_fd_sc_hd__decap_3
XFILLER_0_6_1315 VGND VGND VPWR VPWR sky130_fd_sc_hd__fill_1
XFILLER_0_211_697 VPWR VGND VPWR VGND sky130_ef_sc_hd__decap_12
XFILLER_0_210_163 VGND VGND VPWR VPWR sky130_fd_sc_hd__decap_4
XFILLER_0_112_1117 VPWR VGND VPWR VGND sky130_ef_sc_hd__decap_12
XPHY_322 VGND VGND VPWR VPWR sky130_fd_sc_hd__decap_3
XPHY_311 VGND VGND VPWR VPWR sky130_fd_sc_hd__decap_3
XFILLER_0_13_1225 VPWR VGND VPWR VGND sky130_ef_sc_hd__decap_12
XFILLER_0_52_1263 VPWR VGND VPWR VGND sky130_ef_sc_hd__decap_12
XPHY_333 VGND VGND VPWR VPWR sky130_fd_sc_hd__decap_3
XPHY_377 VGND VGND VPWR VPWR sky130_fd_sc_hd__decap_3
XPHY_355 VGND VGND VPWR VPWR sky130_fd_sc_hd__decap_3
XPHY_366 VGND VGND VPWR VPWR sky130_fd_sc_hd__decap_3
XFILLER_0_4_1061 VPWR VGND VPWR VGND sky130_ef_sc_hd__decap_12
XPHY_344 VGND VGND VPWR VPWR sky130_fd_sc_hd__decap_3
XFILLER_0_124_605 VPWR VGND VPWR VGND sky130_ef_sc_hd__decap_12
XPHY_388 VGND VGND VPWR VPWR sky130_fd_sc_hd__decap_3
XPHY_399 VGND VGND VPWR VPWR sky130_fd_sc_hd__decap_3
XFILLER_0_191_593 VPWR VGND VPWR VGND sky130_ef_sc_hd__decap_12
XFILLER_0_108_189 VGND VGND VPWR VPWR sky130_fd_sc_hd__decap_6
XFILLER_0_105_841 VPWR VGND VPWR VGND sky130_ef_sc_hd__decap_12
XFILLER_0_162_1251 VPWR VGND VPWR VGND sky130_ef_sc_hd__decap_12
XFILLER_0_123_1213 VPWR VGND VPWR VGND sky130_ef_sc_hd__decap_12
XFILLER_0_197_1303 VGND VGND VPWR VPWR sky130_fd_sc_hd__decap_6
XFILLER_0_219_753 VPWR VGND VPWR VGND sky130_ef_sc_hd__decap_12
XFILLER_0_162_1295 VPWR VGND VPWR VGND sky130_ef_sc_hd__decap_12
XFILLER_0_123_1279 VPWR VGND VPWR VGND sky130_ef_sc_hd__decap_12
XFILLER_0_24_1343 VGND VGND VPWR VPWR sky130_fd_sc_hd__fill_1
XFILLER_0_219_797 VPWR VGND VPWR VGND sky130_ef_sc_hd__decap_12
XFILLER_0_94_1319 VPWR VGND VPWR VGND sky130_ef_sc_hd__decap_12
XFILLER_0_83_39 VGND VGND VPWR VPWR sky130_fd_sc_hd__decap_8
XFILLER_0_221_417 VPWR VGND VPWR VGND sky130_ef_sc_hd__decap_12
XFILLER_0_89_647 VPWR VGND VPWR VGND sky130_ef_sc_hd__decap_12
XFILLER_0_107_57 VPWR VGND VPWR VGND sky130_ef_sc_hd__decap_12
XFILLER_0_202_631 VPWR VGND VPWR VGND sky130_ef_sc_hd__decap_12
XFILLER_0_134_1331 VGND VGND VPWR VPWR sky130_fd_sc_hd__decap_6
XFILLER_0_190_29 VPWR VGND VPWR VGND sky130_ef_sc_hd__decap_12
XFILLER_0_130_1239 VPWR VGND VPWR VGND sky130_ef_sc_hd__decap_12
XFILLER_0_31_1303 VGND VGND VPWR VPWR sky130_fd_sc_hd__decap_6
XFILLER_0_210_1285 VGND VGND VPWR VPWR sky130_fd_sc_hd__decap_3
XFILLER_0_218_3 VPWR VGND VPWR VGND sky130_ef_sc_hd__decap_12
XFILLER_0_115_605 VPWR VGND VPWR VGND sky130_ef_sc_hd__decap_12
XANTENNA_clkbuf_0_clk_A clk VGND VGND VPWR VPWR sky130_fd_sc_hd__diode_2
XFILLER_0_120_3 VPWR VGND VPWR VGND sky130_ef_sc_hd__decap_12
XFILLER_0_182_593 VPWR VGND VPWR VGND sky130_ef_sc_hd__decap_12
XFILLER_0_199_49 VGND VGND VPWR VPWR sky130_fd_sc_hd__fill_1
XFILLER_0_4_357 VGND VGND VPWR VPWR sky130_fd_sc_hd__decap_6
XFILLER_0_68_1281 VGND VGND VPWR VPWR sky130_fd_sc_hd__fill_1
XFILLER_0_114_137 VGND VGND VPWR VPWR sky130_fd_sc_hd__decap_3
XFILLER_0_130_619 VPWR VGND VPWR VGND sky130_ef_sc_hd__decap_12
XFILLER_0_13_647 VPWR VGND VPWR VGND sky130_ef_sc_hd__decap_12
XFILLER_0_141_1335 VGND VGND VPWR VPWR sky130_fd_sc_hd__decap_8
XFILLER_0_111_833 VGND VGND VPWR VPWR sky130_fd_sc_hd__decap_6
XFILLER_0_110_321 VPWR VGND VPWR VGND sky130_ef_sc_hd__decap_12
XFILLER_0_102_1319 VPWR VGND VPWR VGND sky130_ef_sc_hd__decap_12
XFILLER_0_111_877 VPWR VGND VPWR VGND sky130_ef_sc_hd__decap_12
XFILLER_0_110_365 VPWR VGND VPWR VGND sky130_ef_sc_hd__decap_12
XFILLER_0_224_233 VPWR VGND VPWR VGND sky130_ef_sc_hd__decap_12
XFILLER_0_139_1253 VGND VGND VPWR VPWR sky130_fd_sc_hd__fill_1
XFILLER_0_224_277 VPWR VGND VPWR VGND sky130_ef_sc_hd__decap_12
XTAP_2709 VGND VPWR sky130_fd_sc_hd__tapvpwrvgnd_1
XFILLER_0_25_3 VPWR VGND VPWR VGND sky130_ef_sc_hd__decap_12
XFILLER_0_164_41 VGND VGND VPWR VPWR sky130_fd_sc_hd__decap_8
XFILLER_0_221_951 VGND VGND VPWR VPWR sky130_fd_sc_hd__fill_1
XFILLER_0_36_1225 VGND VGND VPWR VPWR sky130_fd_sc_hd__fill_1
XFILLER_0_95_617 VPWR VGND VPWR VGND sky130_ef_sc_hd__decap_12
XFILLER_0_1_1201 VPWR VGND VPWR VGND sky130_ef_sc_hd__decap_12
XFILLER_0_146_1213 VPWR VGND VPWR VGND sky130_ef_sc_hd__decap_12
XFILLER_0_173_593 VPWR VGND VPWR VGND sky130_ef_sc_hd__decap_12
XFILLER_0_1_1245 VPWR VGND VPWR VGND sky130_ef_sc_hd__decap_12
XFILLER_0_1_1289 VPWR VGND VPWR VGND sky130_ef_sc_hd__decap_12
XFILLER_0_82_1201 VPWR VGND VPWR VGND sky130_ef_sc_hd__decap_12
XFILLER_0_105_137 VPWR VGND VPWR VGND sky130_ef_sc_hd__decap_12
XFILLER_0_113_181 VPWR VGND VPWR VGND sky130_ef_sc_hd__decap_12
XFILLER_0_216_701 VPWR VGND VPWR VGND sky130_ef_sc_hd__decap_12
Xinput102 w00[10] VGND VGND VPWR VPWR net102 sky130_fd_sc_hd__buf_1
Xinput135 w10[11] VGND VGND VPWR VPWR net135 sky130_fd_sc_hd__clkbuf_4
XANTENNA_input148_A w10[9] VGND VGND VPWR VPWR sky130_fd_sc_hd__diode_2
Xinput124 w01[1] VGND VGND VPWR VPWR net124 sky130_fd_sc_hd__buf_4
Xinput113 w00[6] VGND VGND VPWR VPWR net113 sky130_fd_sc_hd__buf_1
Xinput146 w10[7] VGND VGND VPWR VPWR net146 sky130_fd_sc_hd__clkbuf_4
Xinput157 w11[2] VGND VGND VPWR VPWR net157 sky130_fd_sc_hd__buf_4
XFILLER_0_188_619 VPWR VGND VPWR VGND sky130_ef_sc_hd__decap_12
XFILLER_0_118_1337 VGND VGND VPWR VPWR sky130_fd_sc_hd__fill_1
XFILLER_0_212_973 VGND VGND VPWR VPWR sky130_fd_sc_hd__decap_6
XFILLER_0_211_461 VPWR VGND VPWR VGND sky130_ef_sc_hd__decap_12
XANTENNA_u_pe00_act_in[14] net6 VGND VGND VPWR VPWR sky130_fd_sc_hd__diode_2
XFILLER_0_86_617 VGND VGND VPWR VPWR sky130_fd_sc_hd__fill_1
XFILLER_0_15_1309 VGND VGND VPWR VPWR sky130_fd_sc_hd__fill_1
XFILLER_0_224_77 VGND VGND VPWR VPWR sky130_fd_sc_hd__decap_6
XPHY_130 VGND VGND VPWR VPWR sky130_fd_sc_hd__decap_3
XPHY_141 VGND VGND VPWR VPWR sky130_fd_sc_hd__decap_3
XPHY_152 VGND VGND VPWR VPWR sky130_fd_sc_hd__decap_3
XPHY_185 VGND VGND VPWR VPWR sky130_fd_sc_hd__decap_3
XPHY_163 VGND VGND VPWR VPWR sky130_fd_sc_hd__decap_3
XPHY_174 VGND VGND VPWR VPWR sky130_fd_sc_hd__decap_3
XFILLER_0_164_593 VPWR VGND VPWR VGND sky130_ef_sc_hd__decap_12
XPHY_196 VGND VGND VPWR VPWR sky130_fd_sc_hd__decap_3
XFILLER_0_105_671 VGND VGND VPWR VPWR sky130_fd_sc_hd__fill_1
XFILLER_0_1_305 VPWR VGND VPWR VGND sky130_ef_sc_hd__decap_12
XFILLER_0_205_1343 VGND VGND VPWR VPWR sky130_fd_sc_hd__fill_1
XFILLER_0_1_349 VPWR VGND VPWR VGND sky130_ef_sc_hd__decap_12
XFILLER_0_10_617 VGND VGND VPWR VPWR sky130_fd_sc_hd__fill_1
XFILLER_0_104_181 VPWR VGND VPWR VGND sky130_ef_sc_hd__decap_12
XFILLER_0_219_561 VPWR VGND VPWR VGND sky130_ef_sc_hd__decap_12
XFILLER_0_94_49 VGND VGND VPWR VPWR sky130_fd_sc_hd__fill_1
XFILLER_0_98_1263 VPWR VGND VPWR VGND sky130_ef_sc_hd__decap_12
XFILLER_0_59_1225 VPWR VGND VPWR VGND sky130_ef_sc_hd__decap_12
XFILLER_0_222_737 VPWR VGND VPWR VGND sky130_ef_sc_hd__decap_12
XFILLER_0_221_225 VPWR VGND VPWR VGND sky130_ef_sc_hd__decap_12
XFILLER_0_187_641 VGND VGND VPWR VPWR sky130_fd_sc_hd__decap_4
XFILLER_0_77_617 VPWR VGND VPWR VGND sky130_ef_sc_hd__decap_12
XFILLER_0_169_1213 VPWR VGND VPWR VGND sky130_ef_sc_hd__decap_12
XFILLER_0_35_1291 VPWR VGND VPWR VGND sky130_ef_sc_hd__decap_12
XFILLER_0_210_1060 VGND VGND VPWR VPWR sky130_fd_sc_hd__decap_4
XFILLER_0_150_10 VPWR VGND VPWR VGND sky130_ef_sc_hd__decap_12
XFILLER_0_210_1093 VGND VGND VPWR VPWR sky130_fd_sc_hd__decap_8
XFILLER_0_169_1279 VPWR VGND VPWR VGND sky130_ef_sc_hd__decap_12
XFILLER_0_155_593 VPWR VGND VPWR VGND sky130_ef_sc_hd__decap_12
XFILLER_0_94_6 VGND VGND VPWR VPWR sky130_fd_sc_hd__fill_2
XFILLER_0_4_121 VPWR VGND VPWR VGND sky130_ef_sc_hd__decap_12
XFILLER_0_4_165 VPWR VGND VPWR VGND sky130_ef_sc_hd__decap_12
XFILLER_0_7_53 VGND VGND VPWR VPWR sky130_fd_sc_hd__decap_3
XFILLER_0_106_1241 VPWR VGND VPWR VGND sky130_ef_sc_hd__decap_12
XFILLER_0_111_641 VPWR VGND VPWR VGND sky130_ef_sc_hd__decap_12
XFILLER_0_106_1285 VPWR VGND VPWR VGND sky130_ef_sc_hd__decap_12
XFILLER_0_111_685 VPWR VGND VPWR VGND sky130_ef_sc_hd__decap_12
XFILLER_0_7_97 VPWR VGND VPWR VGND sky130_ef_sc_hd__decap_12
XFILLER_0_42_1251 VPWR VGND VPWR VGND sky130_ef_sc_hd__decap_12
XFILLER_0_0_393 VGND VGND VPWR VPWR sky130_fd_sc_hd__decap_6
XFILLER_0_42_1295 VPWR VGND VPWR VGND sky130_ef_sc_hd__decap_12
XFILLER_0_77_1303 VGND VGND VPWR VPWR sky130_fd_sc_hd__decap_6
XFILLER_0_110_195 VGND VGND VPWR VPWR sky130_fd_sc_hd__fill_1
XFILLER_0_176_1239 VPWR VGND VPWR VGND sky130_ef_sc_hd__decap_12
XFILLER_0_225_553 VGND VGND VPWR VPWR sky130_fd_sc_hd__decap_6
XFILLER_0_217_1225 VGND VGND VPWR VPWR sky130_fd_sc_hd__decap_6
XFILLER_0_217_1269 VPWR VGND VPWR VGND sky130_ef_sc_hd__decap_12
XTAP_2517 VGND VPWR sky130_fd_sc_hd__tapvpwrvgnd_1
XFILLER_0_225_597 VPWR VGND VPWR VGND sky130_ef_sc_hd__decap_12
XTAP_2506 VGND VPWR sky130_fd_sc_hd__tapvpwrvgnd_1
XTAP_2539 VGND VPWR sky130_fd_sc_hd__tapvpwrvgnd_1
XTAP_2528 VGND VPWR sky130_fd_sc_hd__tapvpwrvgnd_1
XTAP_1816 VGND VPWR sky130_fd_sc_hd__tapvpwrvgnd_1
XFILLER_0_68_617 VGND VGND VPWR VPWR sky130_fd_sc_hd__fill_1
XTAP_1805 VGND VPWR sky130_fd_sc_hd__tapvpwrvgnd_1
XFILLER_0_113_1201 VPWR VGND VPWR VGND sky130_ef_sc_hd__decap_12
XTAP_1827 VGND VPWR sky130_fd_sc_hd__tapvpwrvgnd_1
XTAP_1838 VGND VPWR sky130_fd_sc_hd__tapvpwrvgnd_1
XTAP_1849 VGND VPWR sky130_fd_sc_hd__tapvpwrvgnd_1
XFILLER_0_152_1283 VPWR VGND VPWR VGND sky130_ef_sc_hd__decap_12
XFILLER_0_113_1245 VPWR VGND VPWR VGND sky130_ef_sc_hd__decap_12
XFILLER_0_14_1331 VGND VGND VPWR VPWR sky130_fd_sc_hd__decap_6
XFILLER_0_187_1335 VGND VGND VPWR VPWR sky130_fd_sc_hd__decap_8
XFILLER_0_113_1289 VPWR VGND VPWR VGND sky130_ef_sc_hd__decap_12
XFILLER_0_148_1319 VPWR VGND VPWR VGND sky130_ef_sc_hd__decap_12
XFILLER_0_10_1239 VPWR VGND VPWR VGND sky130_ef_sc_hd__decap_12
XFILLER_0_106_413 VGND VGND VPWR VPWR sky130_fd_sc_hd__decap_6
XFILLER_0_210_13 VPWR VGND VPWR VGND sky130_ef_sc_hd__decap_12
XFILLER_0_146_593 VPWR VGND VPWR VGND sky130_ef_sc_hd__decap_12
XFILLER_0_84_1307 VPWR VGND VPWR VGND sky130_ef_sc_hd__decap_12
XFILLER_0_106_457 VPWR VGND VPWR VGND sky130_ef_sc_hd__decap_12
XFILLER_0_224_1229 VPWR VGND VPWR VGND sky130_ef_sc_hd__decap_12
XFILLER_0_210_57 VPWR VGND VPWR VGND sky130_ef_sc_hd__decap_12
XFILLER_0_120_1227 VPWR VGND VPWR VGND sky130_ef_sc_hd__decap_12
XFILLER_0_219_55 VGND VGND VPWR VPWR sky130_fd_sc_hd__fill_1
XFILLER_0_21_1335 VGND VGND VPWR VPWR sky130_fd_sc_hd__decap_8
XFILLER_0_200_1251 VPWR VGND VPWR VGND sky130_ef_sc_hd__decap_12
XFILLER_0_194_1339 VGND VGND VPWR VPWR sky130_fd_sc_hd__decap_4
XFILLER_0_216_531 VGND VGND VPWR VPWR sky130_fd_sc_hd__fill_1
XFILLER_0_200_1295 VPWR VGND VPWR VGND sky130_ef_sc_hd__decap_12
XFILLER_0_114_1009 VPWR VGND VPWR VGND sky130_ef_sc_hd__decap_12
XFILLER_0_169_641 VGND VGND VPWR VPWR sky130_fd_sc_hd__decap_4
XFILLER_0_59_617 VPWR VGND VPWR VGND sky130_ef_sc_hd__decap_12
XFILLER_0_19_1253 VGND VGND VPWR VPWR sky130_fd_sc_hd__fill_1
XFILLER_0_212_781 VPWR VGND VPWR VGND sky130_ef_sc_hd__decap_12
XANTENNA_u_pe10_act_in[13] net21 VGND VGND VPWR VPWR sky130_fd_sc_hd__diode_2
XFILLER_0_80_29 VPWR VGND VPWR VGND sky130_ef_sc_hd__decap_12
XFILLER_0_131_1323 VPWR VGND VPWR VGND sky130_ef_sc_hd__decap_12
XFILLER_0_184_655 VGND VGND VPWR VPWR sky130_fd_sc_hd__decap_4
XFILLER_0_7_909 VPWR VGND VPWR VGND sky130_ef_sc_hd__decap_12
XFILLER_0_82_631 VPWR VGND VPWR VGND sky130_ef_sc_hd__decap_12
XFILLER_0_104_69 VPWR VGND VPWR VGND sky130_ef_sc_hd__decap_12
XFILLER_0_6_419 VGND VGND VPWR VPWR sky130_fd_sc_hd__fill_1
XFILLER_0_109_273 VGND VGND VPWR VPWR sky130_fd_sc_hd__decap_6
XFILLER_0_137_593 VPWR VGND VPWR VGND sky130_ef_sc_hd__decap_12
XFILLER_0_89_27 VPWR VGND VPWR VGND sky130_ef_sc_hd__decap_12
XFILLER_0_2_625 VPWR VGND VPWR VGND sky130_ef_sc_hd__decap_12
XFILLER_0_1_113 VPWR VGND VPWR VGND sky130_ef_sc_hd__decap_12
XFILLER_0_26_1213 VPWR VGND VPWR VGND sky130_ef_sc_hd__decap_12
XFILLER_0_2_669 VPWR VGND VPWR VGND sky130_ef_sc_hd__decap_12
XFILLER_0_59_9 VGND VGND VPWR VPWR sky130_fd_sc_hd__fill_2
XFILLER_0_129_22 VPWR VGND VPWR VGND sky130_ef_sc_hd__decap_12
XFILLER_0_219_391 VGND VGND VPWR VPWR sky130_fd_sc_hd__fill_1
XFILLER_0_222_501 VPWR VGND VPWR VGND sky130_ef_sc_hd__decap_12
XFILLER_0_136_1201 VPWR VGND VPWR VGND sky130_ef_sc_hd__decap_12
XFILLER_0_222_545 VPWR VGND VPWR VGND sky130_ef_sc_hd__decap_12
XFILLER_0_54_41 VGND VGND VPWR VPWR sky130_fd_sc_hd__decap_8
XFILLER_0_222_589 VPWR VGND VPWR VGND sky130_ef_sc_hd__decap_12
XFILLER_0_210_729 VPWR VGND VPWR VGND sky130_ef_sc_hd__decap_12
XFILLER_0_175_655 VGND VGND VPWR VPWR sky130_fd_sc_hd__fill_2
XFILLER_0_128_593 VPWR VGND VPWR VGND sky130_ef_sc_hd__decap_12
XFILLER_0_92_3 VPWR VGND VPWR VGND sky130_ef_sc_hd__decap_12
XFILLER_0_5_441 VGND VGND VPWR VPWR sky130_fd_sc_hd__decap_6
XFILLER_0_5_485 VPWR VGND VPWR VGND sky130_ef_sc_hd__decap_12
XANTENNA_u_pe11_weight_in[15] net155 VGND VGND VPWR VPWR sky130_fd_sc_hd__diode_2
XANTENNA_u_pe01_psum_in[29] net87 VGND VGND VPWR VPWR sky130_fd_sc_hd__diode_2
XFILLER_0_143_1249 VGND VGND VPWR VPWR sky130_fd_sc_hd__decap_4
XFILLER_0_112_961 VPWR VGND VPWR VGND sky130_ef_sc_hd__decap_12
XFILLER_0_217_317 VPWR VGND VPWR VGND sky130_ef_sc_hd__decap_12
XFILLER_0_106_1093 VPWR VGND VPWR VGND sky130_ef_sc_hd__decap_12
XFILLER_0_225_361 VPWR VGND VPWR VGND sky130_ef_sc_hd__decap_12
XFILLER_0_217_1033 VPWR VGND VPWR VGND sky130_ef_sc_hd__decap_12
XFILLER_0_217_1077 VPWR VGND VPWR VGND sky130_ef_sc_hd__decap_12
XTAP_2325 VGND VPWR sky130_fd_sc_hd__tapvpwrvgnd_1
XTAP_2303 VGND VPWR sky130_fd_sc_hd__tapvpwrvgnd_1
XTAP_2314 VGND VPWR sky130_fd_sc_hd__tapvpwrvgnd_1
XTAP_2347 VGND VPWR sky130_fd_sc_hd__tapvpwrvgnd_1
XTAP_2336 VGND VPWR sky130_fd_sc_hd__tapvpwrvgnd_1
XTAP_2358 VGND VPWR sky130_fd_sc_hd__tapvpwrvgnd_1
XTAP_1613 VGND VPWR sky130_fd_sc_hd__tapvpwrvgnd_1
XTAP_1602 VGND VPWR sky130_fd_sc_hd__tapvpwrvgnd_1
XTAP_1624 VGND VPWR sky130_fd_sc_hd__tapvpwrvgnd_1
XTAP_2369 VGND VPWR sky130_fd_sc_hd__tapvpwrvgnd_1
XTAP_1646 VGND VPWR sky130_fd_sc_hd__tapvpwrvgnd_1
XTAP_1635 VGND VPWR sky130_fd_sc_hd__tapvpwrvgnd_1
XTAP_1657 VGND VPWR sky130_fd_sc_hd__tapvpwrvgnd_1
XFILLER_0_166_655 VGND VGND VPWR VPWR sky130_fd_sc_hd__decap_4
XFILLER_0_7_1273 VPWR VGND VPWR VGND sky130_ef_sc_hd__decap_12
XTAP_1668 VGND VPWR sky130_fd_sc_hd__tapvpwrvgnd_1
XTAP_1679 VGND VPWR sky130_fd_sc_hd__tapvpwrvgnd_1
XFILLER_0_64_631 VPWR VGND VPWR VGND sky130_ef_sc_hd__decap_12
XFILLER_0_181_647 VGND VGND VPWR VPWR sky130_fd_sc_hd__decap_8
XFILLER_0_88_1251 VPWR VGND VPWR VGND sky130_ef_sc_hd__decap_12
XFILLER_0_119_593 VPWR VGND VPWR VGND sky130_ef_sc_hd__decap_12
XFILLER_0_49_1213 VPWR VGND VPWR VGND sky130_ef_sc_hd__decap_12
XFILLER_0_106_221 VPWR VGND VPWR VGND sky130_ef_sc_hd__decap_12
XFILLER_0_88_1295 VPWR VGND VPWR VGND sky130_ef_sc_hd__decap_12
XFILLER_0_107_777 VGND VGND VPWR VPWR sky130_fd_sc_hd__decap_6
XFILLER_0_106_265 VPWR VGND VPWR VGND sky130_ef_sc_hd__decap_12
XANTENNA_input76_A psum_col1_in[19] VGND VGND VPWR VPWR sky130_fd_sc_hd__diode_2
XFILLER_0_224_1037 VPWR VGND VPWR VGND sky130_ef_sc_hd__decap_12
XFILLER_0_49_1279 VPWR VGND VPWR VGND sky130_ef_sc_hd__decap_12
XFILLER_0_159_1201 VPWR VGND VPWR VGND sky130_ef_sc_hd__decap_12
XFILLER_0_198_1283 VPWR VGND VPWR VGND sky130_ef_sc_hd__decap_12
XFILLER_0_159_1267 VPWR VGND VPWR VGND sky130_ef_sc_hd__decap_12
XFILLER_0_217_895 VGND VGND VPWR VPWR sky130_fd_sc_hd__fill_1
XFILLER_0_95_1255 VPWR VGND VPWR VGND sky130_ef_sc_hd__decap_12
XFILLER_0_56_1239 VPWR VGND VPWR VGND sky130_ef_sc_hd__decap_12
XFILLER_0_115_13 VPWR VGND VPWR VGND sky130_ef_sc_hd__decap_12
XTAP_2870 VGND VPWR sky130_fd_sc_hd__tapvpwrvgnd_1
XTAP_2881 VGND VPWR sky130_fd_sc_hd__tapvpwrvgnd_1
XTAP_2892 VGND VPWR sky130_fd_sc_hd__tapvpwrvgnd_1
XFILLER_0_157_655 VGND VGND VPWR VPWR sky130_fd_sc_hd__fill_2
XFILLER_0_166_1227 VPWR VGND VPWR VGND sky130_ef_sc_hd__decap_12
XFILLER_0_32_1283 VPWR VGND VPWR VGND sky130_ef_sc_hd__decap_12
XFILLER_0_207_1213 VPWR VGND VPWR VGND sky130_ef_sc_hd__decap_12
XFILLER_0_200_3 VPWR VGND VPWR VGND sky130_ef_sc_hd__decap_12
XFILLER_0_67_1335 VGND VGND VPWR VPWR sky130_fd_sc_hd__decap_8
XFILLER_0_3_945 VGND VGND VPWR VPWR sky130_fd_sc_hd__decap_6
XFILLER_0_28_1319 VPWR VGND VPWR VGND sky130_ef_sc_hd__decap_12
XFILLER_0_207_1279 VPWR VGND VPWR VGND sky130_ef_sc_hd__decap_12
Xoutput225 net225 VGND VGND VPWR VPWR psum_col1_out[6] sky130_fd_sc_hd__clkbuf_4
XFILLER_0_2_433 VPWR VGND VPWR VGND sky130_ef_sc_hd__decap_12
Xoutput203 net203 VGND VGND VPWR VPWR psum_col1_out[15] sky130_fd_sc_hd__clkbuf_4
Xoutput214 net214 VGND VGND VPWR VPWR psum_col1_out[25] sky130_fd_sc_hd__clkbuf_4
XFILLER_0_3_989 VPWR VGND VPWR VGND sky130_ef_sc_hd__decap_12
XFILLER_0_2_477 VPWR VGND VPWR VGND sky130_ef_sc_hd__decap_12
XFILLER_0_177_1323 VPWR VGND VPWR VGND sky130_ef_sc_hd__decap_12
XFILLER_0_103_1255 VPWR VGND VPWR VGND sky130_ef_sc_hd__decap_12
XFILLER_0_226_169 VGND VGND VPWR VPWR sky130_fd_sc_hd__decap_8
XFILLER_0_214_309 VPWR VGND VPWR VGND sky130_ef_sc_hd__decap_12
XFILLER_0_138_1307 VPWR VGND VPWR VGND sky130_ef_sc_hd__decap_12
XFILLER_0_4_65 VPWR VGND VPWR VGND sky130_ef_sc_hd__decap_12
XFILLER_0_223_821 VPWR VGND VPWR VGND sky130_ef_sc_hd__decap_12
XFILLER_0_223_865 VPWR VGND VPWR VGND sky130_ef_sc_hd__decap_12
XFILLER_0_74_1339 VGND VGND VPWR VPWR sky130_fd_sc_hd__decap_4
XFILLER_0_214_1217 VPWR VGND VPWR VGND sky130_ef_sc_hd__decap_12
XFILLER_0_210_526 VGND VGND VPWR VPWR sky130_fd_sc_hd__decap_6
XFILLER_0_172_41 VGND VGND VPWR VPWR sky130_fd_sc_hd__decap_8
XPHY_718 VGND VGND VPWR VPWR sky130_fd_sc_hd__decap_3
XPHY_707 VGND VGND VPWR VPWR sky130_fd_sc_hd__decap_3
XFILLER_0_148_655 VGND VGND VPWR VPWR sky130_fd_sc_hd__decap_4
XPHY_729 VGND VGND VPWR VPWR sky130_fd_sc_hd__decap_3
XFILLER_0_46_631 VPWR VGND VPWR VGND sky130_ef_sc_hd__decap_12
XFILLER_0_11_1323 VGND VGND VPWR VPWR sky130_fd_sc_hd__fill_1
XFILLER_0_110_1259 VGND VGND VPWR VPWR sky130_fd_sc_hd__fill_1
XFILLER_0_163_647 VGND VGND VPWR VPWR sky130_fd_sc_hd__decap_8
XFILLER_0_61_645 VGND VGND VPWR VPWR sky130_fd_sc_hd__fill_1
XFILLER_0_225_1313 VPWR VGND VPWR VGND sky130_ef_sc_hd__decap_12
XFILLER_0_104_725 VGND VGND VPWR VPWR sky130_fd_sc_hd__decap_3
XFILLER_0_104_769 VPWR VGND VPWR VGND sky130_ef_sc_hd__decap_12
XFILLER_0_5_293 VPWR VGND VPWR VGND sky130_ef_sc_hd__decap_12
XFILLER_0_218_637 VGND VGND VPWR VPWR sky130_fd_sc_hd__decap_6
XFILLER_0_121_1311 VPWR VGND VPWR VGND sky130_ef_sc_hd__decap_12
XFILLER_0_217_125 VPWR VGND VPWR VGND sky130_ef_sc_hd__decap_12
XFILLER_0_217_169 VPWR VGND VPWR VGND sky130_ef_sc_hd__decap_12
XFILLER_0_191_1309 VGND VGND VPWR VPWR sky130_fd_sc_hd__fill_1
XFILLER_0_226_681 VGND VGND VPWR VPWR sky130_fd_sc_hd__fill_2
XANTENNA_input130_A w01[7] VGND VGND VPWR VPWR sky130_fd_sc_hd__diode_2
XTAP_2100 VGND VPWR sky130_fd_sc_hd__tapvpwrvgnd_1
XTAP_2144 VGND VPWR sky130_fd_sc_hd__tapvpwrvgnd_1
XTAP_2133 VGND VPWR sky130_fd_sc_hd__tapvpwrvgnd_1
XTAP_2122 VGND VPWR sky130_fd_sc_hd__tapvpwrvgnd_1
XFILLER_0_9_1335 VGND VGND VPWR VPWR sky130_fd_sc_hd__decap_8
XFILLER_0_16_1201 VPWR VGND VPWR VGND sky130_ef_sc_hd__decap_12
XTAP_2111 VGND VPWR sky130_fd_sc_hd__tapvpwrvgnd_1
XTAP_2155 VGND VPWR sky130_fd_sc_hd__tapvpwrvgnd_1
XTAP_2166 VGND VPWR sky130_fd_sc_hd__tapvpwrvgnd_1
XTAP_1421 VGND VPWR sky130_fd_sc_hd__tapvpwrvgnd_1
XTAP_1410 VGND VPWR sky130_fd_sc_hd__tapvpwrvgnd_1
XTAP_1432 VGND VPWR sky130_fd_sc_hd__tapvpwrvgnd_1
XTAP_2177 VGND VPWR sky130_fd_sc_hd__tapvpwrvgnd_1
XFILLER_0_189_1249 VGND VGND VPWR VPWR sky130_fd_sc_hd__decap_4
XTAP_2199 VGND VPWR sky130_fd_sc_hd__tapvpwrvgnd_1
XTAP_2188 VGND VPWR sky130_fd_sc_hd__tapvpwrvgnd_1
XFILLER_0_139_655 VGND VGND VPWR VPWR sky130_fd_sc_hd__fill_2
XTAP_1454 VGND VPWR sky130_fd_sc_hd__tapvpwrvgnd_1
XTAP_1443 VGND VPWR sky130_fd_sc_hd__tapvpwrvgnd_1
XTAP_1465 VGND VPWR sky130_fd_sc_hd__tapvpwrvgnd_1
XTAP_1498 VGND VPWR sky130_fd_sc_hd__tapvpwrvgnd_1
XTAP_1476 VGND VPWR sky130_fd_sc_hd__tapvpwrvgnd_1
XTAP_1487 VGND VPWR sky130_fd_sc_hd__tapvpwrvgnd_1
XFILLER_0_107_541 VPWR VGND VPWR VGND sky130_ef_sc_hd__decap_12
XFILLER_0_107_585 VPWR VGND VPWR VGND sky130_ef_sc_hd__decap_12
XFILLER_0_10_13 VPWR VGND VPWR VGND sky130_ef_sc_hd__decap_12
XFILLER_0_0_959 VPWR VGND VPWR VGND sky130_ef_sc_hd__decap_12
XFILLER_0_23_1249 VGND VGND VPWR VPWR sky130_fd_sc_hd__decap_4
XFILLER_0_220_813 VPWR VGND VPWR VGND sky130_ef_sc_hd__decap_12
XFILLER_0_172_1275 VGND VGND VPWR VPWR sky130_fd_sc_hd__decap_6
XFILLER_0_133_1237 VPWR VGND VPWR VGND sky130_ef_sc_hd__decap_12
XFILLER_0_28_631 VPWR VGND VPWR VGND sky130_ef_sc_hd__decap_12
XFILLER_0_145_647 VGND VGND VPWR VPWR sky130_fd_sc_hd__decap_8
XFILLER_0_160_617 VGND VGND VPWR VPWR sky130_fd_sc_hd__fill_1
XFILLER_0_43_645 VGND VGND VPWR VPWR sky130_fd_sc_hd__fill_1
XFILLER_0_3_753 VPWR VGND VPWR VGND sky130_ef_sc_hd__decap_12
XFILLER_0_3_797 VPWR VGND VPWR VGND sky130_ef_sc_hd__decap_12
XFILLER_0_80_1343 VGND VGND VPWR VPWR sky130_fd_sc_hd__fill_1
XFILLER_0_55_3 VPWR VGND VPWR VGND sky130_ef_sc_hd__decap_12
XFILLER_0_215_629 VPWR VGND VPWR VGND sky130_ef_sc_hd__decap_12
XFILLER_0_214_139 VGND VGND VPWR VPWR sky130_fd_sc_hd__fill_1
XFILLER_0_39_1201 VPWR VGND VPWR VGND sky130_ef_sc_hd__decap_12
XFILLER_0_78_1283 VPWR VGND VPWR VGND sky130_ef_sc_hd__decap_12
XFILLER_0_218_1161 VPWR VGND VPWR VGND sky130_ef_sc_hd__decap_12
XFILLER_0_190_1331 VGND VGND VPWR VPWR sky130_fd_sc_hd__decap_6
XFILLER_0_223_673 VPWR VGND VPWR VGND sky130_ef_sc_hd__decap_12
XFILLER_0_39_1267 VPWR VGND VPWR VGND sky130_ef_sc_hd__decap_12
XPHY_515 VGND VGND VPWR VPWR sky130_fd_sc_hd__decap_3
XPHY_526 VGND VGND VPWR VPWR sky130_fd_sc_hd__decap_3
XPHY_504 VGND VGND VPWR VPWR sky130_fd_sc_hd__decap_3
XPHY_1114 VGND VGND VPWR VPWR sky130_fd_sc_hd__decap_3
XPHY_1103 VGND VGND VPWR VPWR sky130_fd_sc_hd__decap_3
XFILLER_0_210_389 VGND VGND VPWR VPWR sky130_fd_sc_hd__decap_3
XPHY_548 VGND VGND VPWR VPWR sky130_fd_sc_hd__decap_3
XPHY_537 VGND VGND VPWR VPWR sky130_fd_sc_hd__decap_3
XFILLER_0_109_839 VGND VGND VPWR VPWR sky130_fd_sc_hd__fill_1
XPHY_559 VGND VGND VPWR VPWR sky130_fd_sc_hd__decap_3
XPHY_1147 VGND VGND VPWR VPWR sky130_fd_sc_hd__decap_3
XPHY_1136 VGND VGND VPWR VPWR sky130_fd_sc_hd__decap_3
XPHY_1125 VGND VGND VPWR VPWR sky130_fd_sc_hd__decap_3
XPHY_1158 VGND VGND VPWR VPWR sky130_fd_sc_hd__decap_3
XPHY_1169 VGND VGND VPWR VPWR sky130_fd_sc_hd__decap_3
XFILLER_0_149_1255 VPWR VGND VPWR VGND sky130_ef_sc_hd__decap_12
XFILLER_0_151_617 VPWR VGND VPWR VGND sky130_ef_sc_hd__decap_12
XFILLER_0_225_1121 VPWR VGND VPWR VGND sky130_ef_sc_hd__decap_12
XFILLER_0_104_533 VPWR VGND VPWR VGND sky130_ef_sc_hd__decap_12
XFILLER_0_46_1227 VPWR VGND VPWR VGND sky130_ef_sc_hd__decap_12
XFILLER_0_221_1007 VGND VGND VPWR VPWR sky130_fd_sc_hd__fill_1
XFILLER_0_218_401 VPWR VGND VPWR VGND sky130_ef_sc_hd__decap_12
XFILLER_0_218_445 VPWR VGND VPWR VGND sky130_ef_sc_hd__decap_12
XANTENNA_input39_A psum_col0_in[14] VGND VGND VPWR VPWR sky130_fd_sc_hd__diode_2
XFILLER_0_195_1253 VGND VGND VPWR VPWR sky130_fd_sc_hd__fill_1
XFILLER_0_218_489 VPWR VGND VPWR VGND sky130_ef_sc_hd__decap_12
XFILLER_0_92_1225 VGND VGND VPWR VPWR sky130_fd_sc_hd__fill_1
XFILLER_0_57_1323 VPWR VGND VPWR VGND sky130_ef_sc_hd__decap_12
XFILLER_0_220_109 VPWR VGND VPWR VGND sky130_ef_sc_hd__decap_12
XFILLER_0_213_161 VGND VGND VPWR VPWR sky130_fd_sc_hd__decap_6
XFILLER_0_18_1307 VPWR VGND VPWR VGND sky130_ef_sc_hd__decap_12
XTAP_1240 VGND VPWR sky130_fd_sc_hd__tapvpwrvgnd_1
XFILLER_0_5_1007 VGND VGND VPWR VPWR sky130_fd_sc_hd__fill_1
XFILLER_0_132_1281 VGND VGND VPWR VPWR sky130_fd_sc_hd__fill_1
XTAP_1251 VGND VPWR sky130_fd_sc_hd__tapvpwrvgnd_1
XTAP_1273 VGND VPWR sky130_fd_sc_hd__tapvpwrvgnd_1
XTAP_1284 VGND VPWR sky130_fd_sc_hd__tapvpwrvgnd_1
XTAP_1262 VGND VPWR sky130_fd_sc_hd__tapvpwrvgnd_1
XFILLER_0_167_1311 VPWR VGND VPWR VGND sky130_ef_sc_hd__decap_12
XFILLER_0_127_647 VGND VGND VPWR VPWR sky130_fd_sc_hd__decap_8
XTAP_1295 VGND VPWR sky130_fd_sc_hd__tapvpwrvgnd_1
XFILLER_0_142_617 VGND VGND VPWR VPWR sky130_fd_sc_hd__fill_1
XFILLER_0_108_861 VGND VGND VPWR VPWR sky130_fd_sc_hd__decap_6
XFILLER_0_21_45 VGND VGND VPWR VPWR sky130_fd_sc_hd__decap_3
XFILLER_0_128_1339 VGND VGND VPWR VPWR sky130_fd_sc_hd__decap_4
XFILLER_0_25_645 VGND VGND VPWR VPWR sky130_fd_sc_hd__fill_1
XFILLER_0_188_29 VPWR VGND VPWR VGND sky130_ef_sc_hd__decap_12
XFILLER_0_97_27 VPWR VGND VPWR VGND sky130_ef_sc_hd__decap_12
XFILLER_0_107_393 VPWR VGND VPWR VGND sky130_ef_sc_hd__decap_12
XFILLER_0_204_1227 VPWR VGND VPWR VGND sky130_ef_sc_hd__decap_12
XFILLER_0_0_701 VGND VGND VPWR VPWR sky130_fd_sc_hd__decap_6
XFILLER_0_110_525 VGND VGND VPWR VPWR sky130_fd_sc_hd__decap_6
XFILLER_0_198_3 VPWR VGND VPWR VGND sky130_ef_sc_hd__decap_12
XFILLER_0_110_569 VPWR VGND VPWR VGND sky130_ef_sc_hd__decap_12
XFILLER_0_100_1225 VGND VGND VPWR VPWR sky130_fd_sc_hd__fill_1
XANTENNA_u_pe10_weight_in[5] net144 VGND VGND VPWR VPWR sky130_fd_sc_hd__diode_2
XFILLER_0_174_1337 VGND VGND VPWR VPWR sky130_fd_sc_hd__fill_1
XFILLER_0_215_1301 VPWR VGND VPWR VGND sky130_ef_sc_hd__decap_12
XFILLER_0_220_643 VGND VGND VPWR VPWR sky130_fd_sc_hd__fill_1
XFILLER_0_1_55 VGND VGND VPWR VPWR sky130_fd_sc_hd__fill_1
XFILLER_0_71_1309 VGND VGND VPWR VPWR sky130_fd_sc_hd__fill_1
XFILLER_0_62_41 VGND VGND VPWR VPWR sky130_fd_sc_hd__decap_8
XFILLER_0_111_1343 VGND VGND VPWR VPWR sky130_fd_sc_hd__fill_1
XFILLER_0_7_333 VGND VGND VPWR VPWR sky130_fd_sc_hd__decap_3
XFILLER_0_133_617 VPWR VGND VPWR VGND sky130_ef_sc_hd__decap_12
XFILLER_0_69_1249 VGND VGND VPWR VPWR sky130_fd_sc_hd__decap_4
XFILLER_0_114_853 VPWR VGND VPWR VGND sky130_ef_sc_hd__decap_12
XFILLER_0_114_897 VPWR VGND VPWR VGND sky130_ef_sc_hd__decap_12
XFILLER_0_3_561 VPWR VGND VPWR VGND sky130_ef_sc_hd__decap_12
XFILLER_0_113_385 VGND VGND VPWR VPWR sky130_fd_sc_hd__decap_6
XFILLER_0_179_1237 VPWR VGND VPWR VGND sky130_ef_sc_hd__decap_12
XFILLER_0_105_1169 VGND VGND VPWR VPWR sky130_fd_sc_hd__decap_6
XFILLER_0_220_1073 VPWR VGND VPWR VGND sky130_ef_sc_hd__decap_12
XFILLER_0_216_905 VPWR VGND VPWR VGND sky130_ef_sc_hd__decap_12
XFILLER_0_216_949 VPWR VGND VPWR VGND sky130_ef_sc_hd__decap_12
XFILLER_0_224_993 VPWR VGND VPWR VGND sky130_ef_sc_hd__decap_12
XFILLER_0_211_665 VGND VGND VPWR VPWR sky130_fd_sc_hd__decap_6
XPHY_301 VGND VGND VPWR VPWR sky130_fd_sc_hd__decap_3
XFILLER_0_213_13 VPWR VGND VPWR VGND sky130_ef_sc_hd__decap_12
XFILLER_0_112_1129 VPWR VGND VPWR VGND sky130_ef_sc_hd__decap_12
XFILLER_0_91_1291 VPWR VGND VPWR VGND sky130_ef_sc_hd__decap_12
XPHY_323 VGND VGND VPWR VPWR sky130_fd_sc_hd__decap_3
XPHY_334 VGND VGND VPWR VPWR sky130_fd_sc_hd__decap_3
XPHY_312 VGND VGND VPWR VPWR sky130_fd_sc_hd__decap_3
XFILLER_0_213_57 VPWR VGND VPWR VGND sky130_ef_sc_hd__decap_12
XFILLER_0_210_197 VPWR VGND VPWR VGND sky130_ef_sc_hd__decap_12
XPHY_367 VGND VGND VPWR VPWR sky130_fd_sc_hd__decap_3
XFILLER_0_13_1237 VPWR VGND VPWR VGND sky130_ef_sc_hd__decap_12
XFILLER_0_52_1275 VGND VGND VPWR VPWR sky130_fd_sc_hd__decap_6
XPHY_345 VGND VGND VPWR VPWR sky130_fd_sc_hd__decap_3
XPHY_356 VGND VGND VPWR VPWR sky130_fd_sc_hd__decap_3
XPHY_389 VGND VGND VPWR VPWR sky130_fd_sc_hd__decap_3
XPHY_378 VGND VGND VPWR VPWR sky130_fd_sc_hd__decap_3
XFILLER_0_4_1073 VPWR VGND VPWR VGND sky130_ef_sc_hd__decap_12
XFILLER_0_124_617 VGND VGND VPWR VPWR sky130_fd_sc_hd__fill_1
XFILLER_0_105_853 VPWR VGND VPWR VGND sky130_ef_sc_hd__decap_12
XFILLER_0_105_897 VPWR VGND VPWR VGND sky130_ef_sc_hd__decap_12
XFILLER_0_162_1263 VPWR VGND VPWR VGND sky130_ef_sc_hd__decap_12
XFILLER_0_123_1225 VPWR VGND VPWR VGND sky130_ef_sc_hd__decap_12
XFILLER_0_104_385 VGND VGND VPWR VPWR sky130_fd_sc_hd__fill_2
XFILLER_0_219_721 VGND VGND VPWR VPWR sky130_fd_sc_hd__decap_6
XFILLER_0_219_765 VPWR VGND VPWR VGND sky130_ef_sc_hd__decap_12
XFILLER_0_218_253 VPWR VGND VPWR VGND sky130_ef_sc_hd__decap_12
XFILLER_0_221_429 VPWR VGND VPWR VGND sky130_ef_sc_hd__decap_12
XFILLER_0_202_643 VPWR VGND VPWR VGND sky130_ef_sc_hd__decap_12
XFILLER_0_107_69 VPWR VGND VPWR VGND sky130_ef_sc_hd__decap_12
XFILLER_0_134_1343 VGND VGND VPWR VPWR sky130_fd_sc_hd__fill_1
XFILLER_0_70_1331 VGND VGND VPWR VPWR sky130_fd_sc_hd__decap_6
XPHY_890 VGND VGND VPWR VPWR sky130_fd_sc_hd__decap_3
XFILLER_0_115_617 VPWR VGND VPWR VGND sky130_ef_sc_hd__decap_12
XFILLER_0_113_3 VPWR VGND VPWR VGND sky130_ef_sc_hd__decap_12
XFILLER_0_29_1255 VPWR VGND VPWR VGND sky130_ef_sc_hd__decap_12
XFILLER_0_141_1303 VGND VGND VPWR VPWR sky130_fd_sc_hd__decap_6
XFILLER_0_0_531 VGND VGND VPWR VPWR sky130_fd_sc_hd__fill_1
XFILLER_0_111_889 VGND VGND VPWR VPWR sky130_fd_sc_hd__decap_6
XFILLER_0_110_333 VPWR VGND VPWR VGND sky130_ef_sc_hd__decap_12
XFILLER_0_110_377 VPWR VGND VPWR VGND sky130_ef_sc_hd__decap_12
XFILLER_0_178_1281 VGND VGND VPWR VPWR sky130_fd_sc_hd__fill_1
XFILLER_0_224_245 VGND VGND VPWR VPWR sky130_fd_sc_hd__decap_6
XFILLER_0_224_289 VPWR VGND VPWR VGND sky130_ef_sc_hd__decap_12
XFILLER_0_18_3 VPWR VGND VPWR VGND sky130_ef_sc_hd__decap_12
XFILLER_0_75_1253 VGND VGND VPWR VPWR sky130_fd_sc_hd__fill_1
XFILLER_0_215_1175 VGND VGND VPWR VPWR sky130_fd_sc_hd__fill_1
XFILLER_0_95_629 VPWR VGND VPWR VGND sky130_ef_sc_hd__decap_12
XFILLER_0_180_41 VGND VGND VPWR VPWR sky130_fd_sc_hd__decap_8
XFILLER_0_8_631 VPWR VGND VPWR VGND sky130_ef_sc_hd__decap_12
XFILLER_0_7_141 VPWR VGND VPWR VGND sky130_ef_sc_hd__decap_12
XFILLER_0_1_1213 VPWR VGND VPWR VGND sky130_ef_sc_hd__decap_12
XFILLER_0_1_1257 VPWR VGND VPWR VGND sky130_ef_sc_hd__decap_12
XFILLER_0_12_1281 VGND VGND VPWR VPWR sky130_fd_sc_hd__fill_1
XFILLER_0_105_105 VGND VGND VPWR VPWR sky130_fd_sc_hd__decap_6
XFILLER_0_146_1225 VGND VGND VPWR VPWR sky130_fd_sc_hd__fill_1
XFILLER_0_47_1311 VPWR VGND VPWR VGND sky130_ef_sc_hd__decap_12
XFILLER_0_105_149 VPWR VGND VPWR VGND sky130_ef_sc_hd__decap_12
XFILLER_0_82_1213 VPWR VGND VPWR VGND sky130_ef_sc_hd__decap_12
XFILLER_0_226_1293 VGND VGND VPWR VPWR sky130_fd_sc_hd__decap_6
XFILLER_0_226_1271 VGND VGND VPWR VPWR sky130_fd_sc_hd__decap_6
XFILLER_0_4_881 VPWR VGND VPWR VGND sky130_ef_sc_hd__decap_12
XFILLER_0_3_391 VGND VGND VPWR VPWR sky130_fd_sc_hd__fill_1
XFILLER_0_113_193 VPWR VGND VPWR VGND sky130_ef_sc_hd__decap_12
XFILLER_0_216_713 VPWR VGND VPWR VGND sky130_ef_sc_hd__decap_12
Xinput136 w10[12] VGND VGND VPWR VPWR net136 sky130_fd_sc_hd__clkbuf_4
Xinput125 w01[2] VGND VGND VPWR VPWR net125 sky130_fd_sc_hd__buf_4
Xinput114 w00[7] VGND VGND VPWR VPWR net114 sky130_fd_sc_hd__buf_1
Xinput103 w00[11] VGND VGND VPWR VPWR net103 sky130_fd_sc_hd__buf_1
XFILLER_0_192_1201 VPWR VGND VPWR VGND sky130_ef_sc_hd__decap_12
XFILLER_0_216_757 VPWR VGND VPWR VGND sky130_ef_sc_hd__decap_12
XFILLER_0_215_223 VGND VGND VPWR VPWR sky130_fd_sc_hd__fill_1
Xinput147 w10[8] VGND VGND VPWR VPWR net147 sky130_fd_sc_hd__clkbuf_4
XFILLER_0_157_1343 VGND VGND VPWR VPWR sky130_fd_sc_hd__fill_1
Xinput158 w11[3] VGND VGND VPWR VPWR net158 sky130_fd_sc_hd__buf_4
XFILLER_0_196_631 VPWR VGND VPWR VGND sky130_ef_sc_hd__decap_12
XANTENNA_u_pe00_act_in[13] net5 VGND VGND VPWR VPWR sky130_fd_sc_hd__diode_2
XFILLER_0_54_1337 VGND VGND VPWR VPWR sky130_fd_sc_hd__fill_1
XFILLER_0_211_473 VPWR VGND VPWR VGND sky130_ef_sc_hd__decap_12
XPHY_142 VGND VGND VPWR VPWR sky130_fd_sc_hd__decap_3
XPHY_131 VGND VGND VPWR VPWR sky130_fd_sc_hd__decap_3
XPHY_120 VGND VGND VPWR VPWR sky130_fd_sc_hd__decap_3
XPHY_175 VGND VGND VPWR VPWR sky130_fd_sc_hd__decap_3
XPHY_153 VGND VGND VPWR VPWR sky130_fd_sc_hd__decap_3
XPHY_164 VGND VGND VPWR VPWR sky130_fd_sc_hd__decap_3
XPHY_197 VGND VGND VPWR VPWR sky130_fd_sc_hd__decap_3
XPHY_186 VGND VGND VPWR VPWR sky130_fd_sc_hd__decap_3
XFILLER_0_205_1311 VPWR VGND VPWR VGND sky130_ef_sc_hd__decap_12
XFILLER_0_125_1309 VGND VGND VPWR VPWR sky130_fd_sc_hd__fill_1
XFILLER_0_78_29 VPWR VGND VPWR VGND sky130_ef_sc_hd__decap_12
XFILLER_0_120_631 VPWR VGND VPWR VGND sky130_ef_sc_hd__decap_12
XFILLER_0_1_317 VPWR VGND VPWR VGND sky130_ef_sc_hd__decap_12
XFILLER_0_104_193 VGND VGND VPWR VPWR sky130_fd_sc_hd__decap_3
XFILLER_0_219_573 VPWR VGND VPWR VGND sky130_ef_sc_hd__decap_12
XFILLER_0_98_1275 VGND VGND VPWR VPWR sky130_fd_sc_hd__decap_6
XFILLER_0_59_1237 VPWR VGND VPWR VGND sky130_ef_sc_hd__decap_12
XFILLER_0_222_749 VGND VGND VPWR VPWR sky130_fd_sc_hd__decap_6
XFILLER_0_221_237 VPWR VGND VPWR VGND sky130_ef_sc_hd__decap_12
XFILLER_0_77_629 VPWR VGND VPWR VGND sky130_ef_sc_hd__decap_12
XFILLER_0_212_1315 VGND VGND VPWR VPWR sky130_fd_sc_hd__fill_1
XPHY_0 VGND VGND VPWR VPWR sky130_fd_sc_hd__decap_3
XFILLER_0_169_1225 VPWR VGND VPWR VGND sky130_ef_sc_hd__decap_12
XFILLER_0_150_22 VGND VGND VPWR VPWR sky130_fd_sc_hd__decap_6
XFILLER_0_4_133 VGND VGND VPWR VPWR sky130_fd_sc_hd__decap_6
XFILLER_0_87_6 VGND VGND VPWR VPWR sky130_fd_sc_hd__fill_2
XANTENNA_u_pe00_psum_in[29] net55 VGND VGND VPWR VPWR sky130_fd_sc_hd__diode_2
XFILLER_0_4_177 VPWR VGND VPWR VGND sky130_ef_sc_hd__decap_12
XFILLER_0_145_1291 VPWR VGND VPWR VGND sky130_ef_sc_hd__decap_12
XFILLER_0_106_1253 VGND VGND VPWR VPWR sky130_fd_sc_hd__decap_6
XFILLER_0_111_653 VPWR VGND VPWR VGND sky130_ef_sc_hd__decap_12
XFILLER_0_110_141 VPWR VGND VPWR VGND sky130_ef_sc_hd__decap_12
XFILLER_0_106_1297 VPWR VGND VPWR VGND sky130_ef_sc_hd__decap_12
XFILLER_0_111_697 VPWR VGND VPWR VGND sky130_ef_sc_hd__decap_12
XFILLER_0_1_895 VGND VGND VPWR VPWR sky130_fd_sc_hd__fill_1
XFILLER_0_0_361 VGND VGND VPWR VPWR sky130_fd_sc_hd__decap_3
XFILLER_0_0_383 VGND VGND VPWR VPWR sky130_fd_sc_hd__decap_8
XFILLER_0_42_1263 VPWR VGND VPWR VGND sky130_ef_sc_hd__decap_12
XFILLER_0_213_727 VGND VGND VPWR VPWR sky130_fd_sc_hd__fill_1
XTAP_2507 VGND VPWR sky130_fd_sc_hd__tapvpwrvgnd_1
XTAP_2518 VGND VPWR sky130_fd_sc_hd__tapvpwrvgnd_1
XFILLER_0_178_631 VPWR VGND VPWR VGND sky130_ef_sc_hd__decap_12
XTAP_2529 VGND VPWR sky130_fd_sc_hd__tapvpwrvgnd_1
XTAP_1806 VGND VPWR sky130_fd_sc_hd__tapvpwrvgnd_1
XFILLER_0_152_1251 VPWR VGND VPWR VGND sky130_ef_sc_hd__decap_12
XFILLER_0_113_1213 VPWR VGND VPWR VGND sky130_ef_sc_hd__decap_12
XTAP_1828 VGND VPWR sky130_fd_sc_hd__tapvpwrvgnd_1
XTAP_1817 VGND VPWR sky130_fd_sc_hd__tapvpwrvgnd_1
XTAP_1839 VGND VPWR sky130_fd_sc_hd__tapvpwrvgnd_1
XFILLER_0_187_1303 VGND VGND VPWR VPWR sky130_fd_sc_hd__decap_6
XFILLER_0_193_645 VGND VGND VPWR VPWR sky130_fd_sc_hd__fill_1
XFILLER_0_152_1295 VPWR VGND VPWR VGND sky130_ef_sc_hd__decap_12
XFILLER_0_113_1257 VPWR VGND VPWR VGND sky130_ef_sc_hd__decap_12
XFILLER_0_14_1343 VGND VGND VPWR VPWR sky130_fd_sc_hd__fill_1
XFILLER_0_1_1021 VPWR VGND VPWR VGND sky130_ef_sc_hd__decap_12
XFILLER_0_1_1065 VPWR VGND VPWR VGND sky130_ef_sc_hd__decap_12
XFILLER_0_84_1319 VPWR VGND VPWR VGND sky130_ef_sc_hd__decap_12
XFILLER_0_210_25 VGND VGND VPWR VPWR sky130_fd_sc_hd__decap_3
XFILLER_0_106_469 VGND VGND VPWR VPWR sky130_fd_sc_hd__decap_6
XFILLER_0_210_69 VPWR VGND VPWR VGND sky130_ef_sc_hd__decap_12
XFILLER_0_124_1331 VGND VGND VPWR VPWR sky130_fd_sc_hd__decap_6
XFILLER_0_102_631 VPWR VGND VPWR VGND sky130_ef_sc_hd__decap_12
XANTENNA_input160_A w11[5] VGND VGND VPWR VPWR sky130_fd_sc_hd__diode_2
XFILLER_0_194_1307 VPWR VGND VPWR VGND sky130_ef_sc_hd__decap_12
XFILLER_0_120_1239 VPWR VGND VPWR VGND sky130_ef_sc_hd__decap_12
XFILLER_0_21_1303 VGND VGND VPWR VPWR sky130_fd_sc_hd__decap_6
XFILLER_0_200_1263 VPWR VGND VPWR VGND sky130_ef_sc_hd__decap_12
XFILLER_0_216_587 VGND VGND VPWR VPWR sky130_fd_sc_hd__fill_1
XANTENNA_input21_A act_row1_in[13] VGND VGND VPWR VPWR sky130_fd_sc_hd__diode_2
XFILLER_0_59_629 VPWR VGND VPWR VGND sky130_ef_sc_hd__decap_12
XFILLER_0_58_1281 VGND VGND VPWR VPWR sky130_fd_sc_hd__fill_1
XFILLER_0_212_793 VPWR VGND VPWR VGND sky130_ef_sc_hd__decap_12
XANTENNA_u_pe10_act_in[12] net20 VGND VGND VPWR VPWR sky130_fd_sc_hd__diode_2
XFILLER_0_211_281 VPWR VGND VPWR VGND sky130_ef_sc_hd__decap_12
XFILLER_0_131_1335 VGND VGND VPWR VPWR sky130_fd_sc_hd__fill_1
XFILLER_0_104_15 VPWR VGND VPWR VGND sky130_ef_sc_hd__decap_12
XFILLER_0_82_643 VPWR VGND VPWR VGND sky130_ef_sc_hd__decap_12
XFILLER_0_89_39 VGND VGND VPWR VPWR sky130_fd_sc_hd__decap_8
XFILLER_0_129_1253 VGND VGND VPWR VPWR sky130_fd_sc_hd__fill_1
XFILLER_0_106_981 VPWR VGND VPWR VGND sky130_ef_sc_hd__decap_12
XFILLER_0_2_637 VGND VGND VPWR VPWR sky130_fd_sc_hd__decap_6
XFILLER_0_1_125 VPWR VGND VPWR VGND sky130_ef_sc_hd__decap_12
XFILLER_0_196_29 VPWR VGND VPWR VGND sky130_ef_sc_hd__decap_12
XFILLER_0_26_1225 VGND VGND VPWR VPWR sky130_fd_sc_hd__fill_1
XFILLER_0_1_169 VPWR VGND VPWR VGND sky130_ef_sc_hd__decap_12
XFILLER_0_129_34 VPWR VGND VPWR VGND sky130_ef_sc_hd__decap_12
XFILLER_0_226_318 VPWR VGND VPWR VGND sky130_ef_sc_hd__decap_12
XFILLER_0_180_3 VPWR VGND VPWR VGND sky130_ef_sc_hd__decap_12
XFILLER_0_222_513 VPWR VGND VPWR VGND sky130_ef_sc_hd__decap_12
XFILLER_0_136_1213 VPWR VGND VPWR VGND sky130_ef_sc_hd__decap_12
XFILLER_0_222_557 VPWR VGND VPWR VGND sky130_ef_sc_hd__decap_12
XFILLER_0_37_1343 VGND VGND VPWR VPWR sky130_fd_sc_hd__fill_1
XFILLER_0_72_1201 VPWR VGND VPWR VGND sky130_ef_sc_hd__decap_12
XFILLER_0_161_10 VPWR VGND VPWR VGND sky130_ef_sc_hd__decap_12
XFILLER_0_175_645 VGND VGND VPWR VPWR sky130_fd_sc_hd__fill_1
XFILLER_0_70_41 VGND VGND VPWR VPWR sky130_fd_sc_hd__decap_8
XFILLER_0_2_1341 VGND VGND VPWR VPWR sky130_fd_sc_hd__decap_3
XFILLER_0_85_3 VPWR VGND VPWR VGND sky130_ef_sc_hd__decap_12
XFILLER_0_108_1315 VGND VGND VPWR VPWR sky130_fd_sc_hd__fill_1
XFILLER_0_5_497 VGND VGND VPWR VPWR sky130_fd_sc_hd__decap_6
XANTENNA_u_pe11_weight_in[14] net154 VGND VGND VPWR VPWR sky130_fd_sc_hd__diode_2
XANTENNA_u_pe01_psum_in[28] net86 VGND VGND VPWR VPWR sky130_fd_sc_hd__diode_2
XFILLER_0_106_1061 VPWR VGND VPWR VGND sky130_ef_sc_hd__decap_12
XFILLER_0_112_973 VGND VGND VPWR VPWR sky130_fd_sc_hd__decap_6
XFILLER_0_111_461 VPWR VGND VPWR VGND sky130_ef_sc_hd__decap_12
XFILLER_0_217_329 VGND VGND VPWR VPWR sky130_fd_sc_hd__decap_6
XFILLER_0_217_1001 VGND VGND VPWR VPWR sky130_fd_sc_hd__decap_6
XFILLER_0_225_373 VPWR VGND VPWR VGND sky130_ef_sc_hd__decap_12
XFILLER_0_217_1045 VPWR VGND VPWR VGND sky130_ef_sc_hd__decap_12
XTAP_2315 VGND VPWR sky130_fd_sc_hd__tapvpwrvgnd_1
XTAP_2304 VGND VPWR sky130_fd_sc_hd__tapvpwrvgnd_1
XTAP_2326 VGND VPWR sky130_fd_sc_hd__tapvpwrvgnd_1
XFILLER_0_217_1089 VPWR VGND VPWR VGND sky130_ef_sc_hd__decap_12
XFILLER_0_205_47 VGND VGND VPWR VPWR sky130_fd_sc_hd__decap_3
XTAP_2359 VGND VPWR sky130_fd_sc_hd__tapvpwrvgnd_1
XTAP_2348 VGND VPWR sky130_fd_sc_hd__tapvpwrvgnd_1
XTAP_1614 VGND VPWR sky130_fd_sc_hd__tapvpwrvgnd_1
XTAP_1603 VGND VPWR sky130_fd_sc_hd__tapvpwrvgnd_1
XTAP_2337 VGND VPWR sky130_fd_sc_hd__tapvpwrvgnd_1
XFILLER_0_113_1021 VPWR VGND VPWR VGND sky130_ef_sc_hd__decap_12
XTAP_1658 VGND VPWR sky130_fd_sc_hd__tapvpwrvgnd_1
XTAP_1625 VGND VPWR sky130_fd_sc_hd__tapvpwrvgnd_1
XTAP_1636 VGND VPWR sky130_fd_sc_hd__tapvpwrvgnd_1
XTAP_1647 VGND VPWR sky130_fd_sc_hd__tapvpwrvgnd_1
XFILLER_0_113_1065 VPWR VGND VPWR VGND sky130_ef_sc_hd__decap_12
XTAP_1669 VGND VPWR sky130_fd_sc_hd__tapvpwrvgnd_1
XFILLER_0_7_1285 VGND VGND VPWR VPWR sky130_fd_sc_hd__decap_3
XFILLER_0_64_643 VPWR VGND VPWR VGND sky130_ef_sc_hd__decap_12
XFILLER_0_221_57 VPWR VGND VPWR VGND sky130_ef_sc_hd__decap_12
XFILLER_0_88_1263 VPWR VGND VPWR VGND sky130_ef_sc_hd__decap_12
XFILLER_0_49_1225 VPWR VGND VPWR VGND sky130_ef_sc_hd__decap_12
XFILLER_0_106_233 VPWR VGND VPWR VGND sky130_ef_sc_hd__decap_12
XFILLER_0_224_1005 VPWR VGND VPWR VGND sky130_ef_sc_hd__decap_12
XFILLER_0_106_277 VPWR VGND VPWR VGND sky130_ef_sc_hd__decap_12
XFILLER_0_224_1049 VPWR VGND VPWR VGND sky130_ef_sc_hd__decap_12
XANTENNA_input69_A psum_col1_in[12] VGND VGND VPWR VPWR sky130_fd_sc_hd__diode_2
XFILLER_0_198_1251 VPWR VGND VPWR VGND sky130_ef_sc_hd__decap_12
XFILLER_0_217_841 VPWR VGND VPWR VGND sky130_ef_sc_hd__decap_12
XFILLER_0_159_1213 VPWR VGND VPWR VGND sky130_ef_sc_hd__decap_12
XFILLER_0_95_1201 VPWR VGND VPWR VGND sky130_ef_sc_hd__decap_12
XFILLER_0_25_1291 VPWR VGND VPWR VGND sky130_ef_sc_hd__decap_12
XFILLER_0_198_1295 VPWR VGND VPWR VGND sky130_ef_sc_hd__decap_12
XFILLER_0_159_1279 VPWR VGND VPWR VGND sky130_ef_sc_hd__decap_12
XFILLER_0_95_1267 VPWR VGND VPWR VGND sky130_ef_sc_hd__decap_12
XFILLER_0_115_25 VPWR VGND VPWR VGND sky130_ef_sc_hd__decap_12
XTAP_2871 VGND VPWR sky130_fd_sc_hd__tapvpwrvgnd_1
XTAP_2860 VGND VPWR sky130_fd_sc_hd__tapvpwrvgnd_1
XTAP_2882 VGND VPWR sky130_fd_sc_hd__tapvpwrvgnd_1
XTAP_2893 VGND VPWR sky130_fd_sc_hd__tapvpwrvgnd_1
XFILLER_0_157_645 VGND VGND VPWR VPWR sky130_fd_sc_hd__fill_1
XFILLER_0_7_729 VPWR VGND VPWR VGND sky130_ef_sc_hd__decap_12
XFILLER_0_32_1251 VPWR VGND VPWR VGND sky130_ef_sc_hd__decap_12
XFILLER_0_166_1239 VPWR VGND VPWR VGND sky130_ef_sc_hd__decap_12
XFILLER_0_32_1295 VPWR VGND VPWR VGND sky130_ef_sc_hd__decap_12
XFILLER_0_67_1303 VGND VGND VPWR VPWR sky130_fd_sc_hd__decap_6
XFILLER_0_207_1225 VPWR VGND VPWR VGND sky130_ef_sc_hd__decap_12
XFILLER_0_2_401 VPWR VGND VPWR VGND sky130_ef_sc_hd__decap_12
Xoutput226 net226 VGND VGND VPWR VPWR psum_col1_out[7] sky130_fd_sc_hd__clkbuf_4
XFILLER_0_2_445 VPWR VGND VPWR VGND sky130_ef_sc_hd__decap_12
Xoutput204 net204 VGND VGND VPWR VPWR psum_col1_out[16] sky130_fd_sc_hd__clkbuf_4
Xoutput215 net215 VGND VGND VPWR VPWR psum_col1_out[26] sky130_fd_sc_hd__clkbuf_4
XFILLER_0_103_1201 VPWR VGND VPWR VGND sky130_ef_sc_hd__decap_12
XFILLER_0_2_489 VPWR VGND VPWR VGND sky130_ef_sc_hd__decap_12
XFILLER_0_142_1283 VPWR VGND VPWR VGND sky130_ef_sc_hd__decap_12
XFILLER_0_177_1335 VGND VGND VPWR VPWR sky130_fd_sc_hd__decap_8
XFILLER_0_103_1267 VPWR VGND VPWR VGND sky130_ef_sc_hd__decap_12
XFILLER_0_138_1319 VPWR VGND VPWR VGND sky130_ef_sc_hd__decap_12
XFILLER_0_223_833 VGND VGND VPWR VPWR sky130_fd_sc_hd__decap_6
XFILLER_0_4_77 VGND VGND VPWR VPWR sky130_fd_sc_hd__decap_6
XFILLER_0_74_1307 VPWR VGND VPWR VGND sky130_ef_sc_hd__decap_12
XFILLER_0_223_877 VPWR VGND VPWR VGND sky130_ef_sc_hd__decap_12
XFILLER_0_222_321 VPWR VGND VPWR VGND sky130_ef_sc_hd__decap_12
XFILLER_0_214_1229 VPWR VGND VPWR VGND sky130_ef_sc_hd__decap_12
XFILLER_0_210_505 VGND VGND VPWR VPWR sky130_fd_sc_hd__decap_4
XFILLER_0_222_365 VPWR VGND VPWR VGND sky130_ef_sc_hd__decap_12
XPHY_708 VGND VGND VPWR VPWR sky130_fd_sc_hd__decap_3
XFILLER_0_114_1341 VGND VGND VPWR VPWR sky130_fd_sc_hd__decap_3
XFILLER_0_110_1205 VPWR VGND VPWR VGND sky130_ef_sc_hd__decap_12
XPHY_719 VGND VGND VPWR VPWR sky130_fd_sc_hd__decap_3
XFILLER_0_46_643 VPWR VGND VPWR VGND sky130_ef_sc_hd__decap_12
XFILLER_0_184_1339 VGND VGND VPWR VPWR sky130_fd_sc_hd__decap_3
XFILLER_0_225_1325 VPWR VGND VPWR VGND sky130_ef_sc_hd__decap_12
XFILLER_0_5_261 VPWR VGND VPWR VGND sky130_ef_sc_hd__decap_12
XFILLER_0_104_1009 VPWR VGND VPWR VGND sky130_ef_sc_hd__decap_12
XFILLER_0_121_1323 VPWR VGND VPWR VGND sky130_ef_sc_hd__decap_12
XFILLER_0_112_781 VPWR VGND VPWR VGND sky130_ef_sc_hd__decap_12
XFILLER_0_217_137 VPWR VGND VPWR VGND sky130_ef_sc_hd__decap_12
XFILLER_0_214_811 VGND VGND VPWR VPWR sky130_fd_sc_hd__fill_1
XFILLER_0_225_181 VPWR VGND VPWR VGND sky130_ef_sc_hd__decap_12
XANTENNA_input123_A w01[15] VGND VGND VPWR VPWR sky130_fd_sc_hd__diode_2
XFILLER_0_9_1303 VGND VGND VPWR VPWR sky130_fd_sc_hd__decap_6
XTAP_2101 VGND VPWR sky130_fd_sc_hd__tapvpwrvgnd_1
XTAP_2134 VGND VPWR sky130_fd_sc_hd__tapvpwrvgnd_1
XTAP_2123 VGND VPWR sky130_fd_sc_hd__tapvpwrvgnd_1
XTAP_2112 VGND VPWR sky130_fd_sc_hd__tapvpwrvgnd_1
XTAP_2167 VGND VPWR sky130_fd_sc_hd__tapvpwrvgnd_1
XTAP_2156 VGND VPWR sky130_fd_sc_hd__tapvpwrvgnd_1
XTAP_1422 VGND VPWR sky130_fd_sc_hd__tapvpwrvgnd_1
XTAP_1411 VGND VPWR sky130_fd_sc_hd__tapvpwrvgnd_1
XTAP_1433 VGND VPWR sky130_fd_sc_hd__tapvpwrvgnd_1
XTAP_1400 VGND VPWR sky130_fd_sc_hd__tapvpwrvgnd_1
XFILLER_0_16_1213 VPWR VGND VPWR VGND sky130_ef_sc_hd__decap_12
XTAP_2145 VGND VPWR sky130_fd_sc_hd__tapvpwrvgnd_1
XTAP_2189 VGND VPWR sky130_fd_sc_hd__tapvpwrvgnd_1
XFILLER_0_139_645 VGND VGND VPWR VPWR sky130_fd_sc_hd__fill_1
XTAP_2178 VGND VPWR sky130_fd_sc_hd__tapvpwrvgnd_1
XTAP_1466 VGND VPWR sky130_fd_sc_hd__tapvpwrvgnd_1
XTAP_1444 VGND VPWR sky130_fd_sc_hd__tapvpwrvgnd_1
XTAP_1455 VGND VPWR sky130_fd_sc_hd__tapvpwrvgnd_1
XTAP_1477 VGND VPWR sky130_fd_sc_hd__tapvpwrvgnd_1
XFILLER_0_7_1093 VPWR VGND VPWR VGND sky130_ef_sc_hd__decap_12
XTAP_1488 VGND VPWR sky130_fd_sc_hd__tapvpwrvgnd_1
XTAP_1499 VGND VPWR sky130_fd_sc_hd__tapvpwrvgnd_1
XFILLER_0_107_553 VGND VGND VPWR VPWR sky130_fd_sc_hd__decap_6
XFILLER_0_126_1201 VPWR VGND VPWR VGND sky130_ef_sc_hd__decap_12
XFILLER_0_107_597 VPWR VGND VPWR VGND sky130_ef_sc_hd__decap_12
XFILLER_0_10_25 VGND VGND VPWR VPWR sky130_fd_sc_hd__decap_3
XFILLER_0_86_29 VPWR VGND VPWR VGND sky130_ef_sc_hd__decap_12
XFILLER_0_209_605 VPWR VGND VPWR VGND sky130_ef_sc_hd__decap_12
XFILLER_0_217_671 VGND VGND VPWR VPWR sky130_fd_sc_hd__fill_1
XFILLER_0_220_825 VPWR VGND VPWR VGND sky130_ef_sc_hd__decap_12
XFILLER_0_220_869 VPWR VGND VPWR VGND sky130_ef_sc_hd__decap_12
XFILLER_0_133_1249 VGND VGND VPWR VPWR sky130_fd_sc_hd__decap_4
XTAP_2690 VGND VPWR sky130_fd_sc_hd__tapvpwrvgnd_1
XFILLER_0_200_593 VPWR VGND VPWR VGND sky130_ef_sc_hd__decap_12
XFILLER_0_28_643 VPWR VGND VPWR VGND sky130_ef_sc_hd__decap_12
XFILLER_0_209_1309 VGND VGND VPWR VPWR sky130_fd_sc_hd__fill_1
XFILLER_0_3_721 VGND VGND VPWR VPWR sky130_fd_sc_hd__decap_6
XFILLER_0_3_765 VPWR VGND VPWR VGND sky130_ef_sc_hd__decap_12
XFILLER_0_2_253 VPWR VGND VPWR VGND sky130_ef_sc_hd__decap_12
XFILLER_0_48_3 VPWR VGND VPWR VGND sky130_ef_sc_hd__decap_12
XFILLER_0_78_1251 VPWR VGND VPWR VGND sky130_ef_sc_hd__decap_12
XFILLER_0_223_641 VPWR VGND VPWR VGND sky130_ef_sc_hd__decap_12
XFILLER_0_39_1213 VPWR VGND VPWR VGND sky130_ef_sc_hd__decap_12
XFILLER_0_78_1295 VPWR VGND VPWR VGND sky130_ef_sc_hd__decap_12
XFILLER_0_218_1173 VPWR VGND VPWR VGND sky130_ef_sc_hd__decap_12
XFILLER_0_223_685 VPWR VGND VPWR VGND sky130_ef_sc_hd__decap_12
XFILLER_0_39_1279 VPWR VGND VPWR VGND sky130_ef_sc_hd__decap_12
XFILLER_0_214_1037 VPWR VGND VPWR VGND sky130_ef_sc_hd__decap_12
XFILLER_0_222_195 VGND VGND VPWR VPWR sky130_fd_sc_hd__fill_1
XPHY_516 VGND VGND VPWR VPWR sky130_fd_sc_hd__decap_3
XPHY_505 VGND VGND VPWR VPWR sky130_fd_sc_hd__decap_3
XPHY_1104 VGND VGND VPWR VPWR sky130_fd_sc_hd__decap_3
XPHY_549 VGND VGND VPWR VPWR sky130_fd_sc_hd__decap_3
XPHY_527 VGND VGND VPWR VPWR sky130_fd_sc_hd__decap_3
XPHY_538 VGND VGND VPWR VPWR sky130_fd_sc_hd__decap_3
XPHY_1126 VGND VGND VPWR VPWR sky130_fd_sc_hd__decap_3
XPHY_1115 VGND VGND VPWR VPWR sky130_fd_sc_hd__decap_3
XPHY_1148 VGND VGND VPWR VPWR sky130_fd_sc_hd__decap_3
XPHY_1137 VGND VGND VPWR VPWR sky130_fd_sc_hd__decap_3
XFILLER_0_202_15 VPWR VGND VPWR VGND sky130_ef_sc_hd__decap_12
XFILLER_0_149_1201 VPWR VGND VPWR VGND sky130_ef_sc_hd__decap_12
XFILLER_0_110_1035 VGND VGND VPWR VPWR sky130_fd_sc_hd__fill_1
XPHY_1159 VGND VGND VPWR VPWR sky130_fd_sc_hd__decap_3
XFILLER_0_188_1283 VPWR VGND VPWR VGND sky130_ef_sc_hd__decap_12
XFILLER_0_149_1267 VPWR VGND VPWR VGND sky130_ef_sc_hd__decap_12
XFILLER_0_151_629 VPWR VGND VPWR VGND sky130_ef_sc_hd__decap_12
XFILLER_0_104_501 VGND VGND VPWR VPWR sky130_fd_sc_hd__decap_3
XFILLER_0_6_581 VGND VGND VPWR VPWR sky130_fd_sc_hd__decap_6
XFILLER_0_85_1255 VPWR VGND VPWR VGND sky130_ef_sc_hd__decap_12
XFILLER_0_225_1133 VPWR VGND VPWR VGND sky130_ef_sc_hd__decap_12
XFILLER_0_104_545 VPWR VGND VPWR VGND sky130_ef_sc_hd__decap_12
XFILLER_0_46_1239 VPWR VGND VPWR VGND sky130_ef_sc_hd__decap_12
XFILLER_0_225_1177 VPWR VGND VPWR VGND sky130_ef_sc_hd__decap_12
XFILLER_0_104_589 VPWR VGND VPWR VGND sky130_ef_sc_hd__decap_12
XFILLER_0_218_413 VGND VGND VPWR VPWR sky130_fd_sc_hd__decap_6
XFILLER_0_206_619 VPWR VGND VPWR VGND sky130_ef_sc_hd__decap_12
XFILLER_0_218_457 VPWR VGND VPWR VGND sky130_ef_sc_hd__decap_12
XFILLER_0_22_1283 VPWR VGND VPWR VGND sky130_ef_sc_hd__decap_12
XFILLER_0_226_490 VPWR VGND VPWR VGND sky130_ef_sc_hd__decap_12
XFILLER_0_156_1227 VPWR VGND VPWR VGND sky130_ef_sc_hd__decap_12
XFILLER_0_57_1335 VGND VGND VPWR VPWR sky130_fd_sc_hd__decap_8
XFILLER_0_18_1319 VPWR VGND VPWR VGND sky130_ef_sc_hd__decap_12
XTAP_1241 VGND VPWR sky130_fd_sc_hd__tapvpwrvgnd_1
XTAP_1230 VGND VPWR sky130_fd_sc_hd__tapvpwrvgnd_1
XFILLER_0_210_880 VPWR VGND VPWR VGND sky130_ef_sc_hd__decap_12
XTAP_1252 VGND VPWR sky130_fd_sc_hd__tapvpwrvgnd_1
XTAP_1274 VGND VPWR sky130_fd_sc_hd__tapvpwrvgnd_1
XTAP_1263 VGND VPWR sky130_fd_sc_hd__tapvpwrvgnd_1
XFILLER_0_21_13 VPWR VGND VPWR VGND sky130_ef_sc_hd__decap_12
XTAP_1296 VGND VPWR sky130_fd_sc_hd__tapvpwrvgnd_1
XTAP_1285 VGND VPWR sky130_fd_sc_hd__tapvpwrvgnd_1
XFILLER_0_167_1323 VPWR VGND VPWR VGND sky130_ef_sc_hd__decap_12
XFILLER_0_128_1307 VPWR VGND VPWR VGND sky130_ef_sc_hd__decap_12
XFILLER_0_107_361 VPWR VGND VPWR VGND sky130_ef_sc_hd__decap_12
XFILLER_0_114_309 VPWR VGND VPWR VGND sky130_ef_sc_hd__decap_12
XFILLER_0_208_1331 VGND VGND VPWR VPWR sky130_fd_sc_hd__decap_6
XFILLER_0_40_605 VPWR VGND VPWR VGND sky130_ef_sc_hd__decap_12
XFILLER_0_108_6 VGND VGND VPWR VPWR sky130_fd_sc_hd__fill_2
XFILLER_0_0_713 VPWR VGND VPWR VGND sky130_ef_sc_hd__decap_12
XFILLER_0_64_1339 VGND VGND VPWR VPWR sky130_fd_sc_hd__decap_4
XFILLER_0_97_39 VGND VGND VPWR VPWR sky130_fd_sc_hd__decap_8
XFILLER_0_204_1239 VPWR VGND VPWR VGND sky130_ef_sc_hd__decap_12
XFILLER_0_0_735 VPWR VGND VPWR VGND sky130_ef_sc_hd__decap_12
XFILLER_0_0_779 VGND VGND VPWR VPWR sky130_fd_sc_hd__decap_4
XANTENNA_u_pe10_weight_in[4] net143 VGND VGND VPWR VPWR sky130_fd_sc_hd__diode_2
XFILLER_0_205_641 VGND VGND VPWR VPWR sky130_fd_sc_hd__decap_4
XFILLER_0_215_1313 VPWR VGND VPWR VGND sky130_ef_sc_hd__decap_12
XFILLER_0_220_699 VGND VGND VPWR VPWR sky130_fd_sc_hd__fill_1
XFILLER_0_181_1309 VGND VGND VPWR VPWR sky130_fd_sc_hd__fill_1
XFILLER_0_133_629 VPWR VGND VPWR VGND sky130_ef_sc_hd__decap_12
XFILLER_0_7_389 VGND VGND VPWR VPWR sky130_fd_sc_hd__decap_3
XFILLER_0_31_605 VPWR VGND VPWR VGND sky130_ef_sc_hd__decap_12
XFILLER_0_222_1317 VPWR VGND VPWR VGND sky130_ef_sc_hd__decap_12
XFILLER_0_178_41 VGND VGND VPWR VPWR sky130_fd_sc_hd__decap_8
XFILLER_0_114_865 VGND VGND VPWR VPWR sky130_fd_sc_hd__decap_3
XFILLER_0_3_573 VPWR VGND VPWR VGND sky130_ef_sc_hd__decap_12
XFILLER_0_179_1249 VGND VGND VPWR VPWR sky130_fd_sc_hd__decap_4
XFILLER_0_216_917 VGND VGND VPWR VPWR sky130_fd_sc_hd__decap_6
XFILLER_0_220_1085 VGND VGND VPWR VPWR sky130_fd_sc_hd__decap_6
XFILLER_0_215_405 VPWR VGND VPWR VGND sky130_ef_sc_hd__decap_12
XFILLER_0_215_449 VPWR VGND VPWR VGND sky130_ef_sc_hd__decap_12
XFILLER_0_98_605 VPWR VGND VPWR VGND sky130_ef_sc_hd__decap_12
XFILLER_0_224_961 VPWR VGND VPWR VGND sky130_ef_sc_hd__decap_12
XFILLER_0_210_121 VPWR VGND VPWR VGND sky130_ef_sc_hd__decap_12
XFILLER_0_6_1317 VPWR VGND VPWR VGND sky130_ef_sc_hd__decap_12
XFILLER_0_213_25 VPWR VGND VPWR VGND sky130_ef_sc_hd__decap_12
XFILLER_0_109_615 VGND VGND VPWR VPWR sky130_fd_sc_hd__fill_1
XPHY_313 VGND VGND VPWR VPWR sky130_fd_sc_hd__decap_3
XPHY_324 VGND VGND VPWR VPWR sky130_fd_sc_hd__decap_3
XPHY_302 VGND VGND VPWR VPWR sky130_fd_sc_hd__decap_3
XFILLER_0_213_69 VPWR VGND VPWR VGND sky130_ef_sc_hd__decap_12
XPHY_346 VGND VGND VPWR VPWR sky130_fd_sc_hd__decap_3
XPHY_335 VGND VGND VPWR VPWR sky130_fd_sc_hd__decap_3
XFILLER_0_13_1249 VGND VGND VPWR VPWR sky130_fd_sc_hd__decap_4
XPHY_357 VGND VGND VPWR VPWR sky130_fd_sc_hd__decap_3
XPHY_368 VGND VGND VPWR VPWR sky130_fd_sc_hd__decap_3
XPHY_379 VGND VGND VPWR VPWR sky130_fd_sc_hd__decap_3
XFILLER_0_4_1085 VGND VGND VPWR VPWR sky130_fd_sc_hd__decap_6
XFILLER_0_105_821 VPWR VGND VPWR VGND sky130_ef_sc_hd__decap_12
XFILLER_0_22_605 VPWR VGND VPWR VGND sky130_ef_sc_hd__decap_12
XFILLER_0_105_865 VPWR VGND VPWR VGND sky130_ef_sc_hd__decap_12
XFILLER_0_162_1275 VGND VGND VPWR VPWR sky130_fd_sc_hd__decap_6
XANTENNA_input51_A psum_col0_in[25] VGND VGND VPWR VPWR sky130_fd_sc_hd__diode_2
XFILLER_0_123_1237 VPWR VGND VPWR VGND sky130_ef_sc_hd__decap_12
XFILLER_0_219_777 VGND VGND VPWR VPWR sky130_fd_sc_hd__decap_6
XFILLER_0_218_221 VPWR VGND VPWR VGND sky130_ef_sc_hd__decap_12
XFILLER_0_218_265 VPWR VGND VPWR VGND sky130_ef_sc_hd__decap_12
XFILLER_0_107_15 VPWR VGND VPWR VGND sky130_ef_sc_hd__decap_12
XFILLER_0_89_605 VPWR VGND VPWR VGND sky130_ef_sc_hd__decap_12
XFILLER_0_202_655 VGND VGND VPWR VPWR sky130_fd_sc_hd__decap_4
XFILLER_0_70_1343 VGND VGND VPWR VPWR sky130_fd_sc_hd__fill_1
XFILLER_0_225_6 VGND VGND VPWR VPWR sky130_fd_sc_hd__fill_2
XFILLER_0_123_47 VGND VGND VPWR VPWR sky130_fd_sc_hd__decap_3
XPHY_880 VGND VGND VPWR VPWR sky130_fd_sc_hd__decap_3
XFILLER_0_115_629 VPWR VGND VPWR VGND sky130_ef_sc_hd__decap_12
XPHY_891 VGND VGND VPWR VPWR sky130_fd_sc_hd__decap_3
XFILLER_0_108_681 VPWR VGND VPWR VGND sky130_ef_sc_hd__decap_12
XFILLER_0_13_605 VPWR VGND VPWR VGND sky130_ef_sc_hd__decap_12
XFILLER_0_29_1201 VPWR VGND VPWR VGND sky130_ef_sc_hd__decap_12
XFILLER_0_106_3 VPWR VGND VPWR VGND sky130_ef_sc_hd__decap_12
XFILLER_0_180_1331 VGND VGND VPWR VPWR sky130_fd_sc_hd__decap_6
XFILLER_0_80_593 VPWR VGND VPWR VGND sky130_ef_sc_hd__decap_12
XFILLER_0_29_1267 VPWR VGND VPWR VGND sky130_ef_sc_hd__decap_12
XFILLER_0_68_1283 VPWR VGND VPWR VGND sky130_ef_sc_hd__decap_12
XFILLER_0_110_301 VGND VGND VPWR VPWR sky130_fd_sc_hd__decap_6
XFILLER_0_110_345 VPWR VGND VPWR VGND sky130_ef_sc_hd__decap_12
XFILLER_0_0_587 VGND VGND VPWR VPWR sky130_fd_sc_hd__fill_1
XFILLER_0_110_389 VPWR VGND VPWR VGND sky130_ef_sc_hd__decap_12
XFILLER_0_213_909 VPWR VGND VPWR VGND sky130_ef_sc_hd__decap_12
XFILLER_0_164_10 VPWR VGND VPWR VGND sky130_ef_sc_hd__decap_12
XFILLER_0_212_419 VGND VGND VPWR VPWR sky130_fd_sc_hd__fill_1
XFILLER_0_139_1255 VPWR VGND VPWR VGND sky130_ef_sc_hd__decap_12
XFILLER_0_215_1121 VPWR VGND VPWR VGND sky130_ef_sc_hd__decap_12
XFILLER_0_36_1227 VPWR VGND VPWR VGND sky130_ef_sc_hd__decap_12
XFILLER_0_221_953 VPWR VGND VPWR VGND sky130_ef_sc_hd__decap_12
XFILLER_0_211_1007 VGND VGND VPWR VPWR sky130_fd_sc_hd__fill_1
XFILLER_0_8_643 VPWR VGND VPWR VGND sky130_ef_sc_hd__decap_12
XFILLER_0_1_1225 VGND VGND VPWR VPWR sky130_fd_sc_hd__decap_6
XFILLER_0_185_1253 VGND VGND VPWR VPWR sky130_fd_sc_hd__fill_1
XFILLER_0_7_153 VPWR VGND VPWR VGND sky130_ef_sc_hd__decap_12
XFILLER_0_1_1269 VPWR VGND VPWR VGND sky130_ef_sc_hd__decap_12
XFILLER_0_7_197 VPWR VGND VPWR VGND sky130_ef_sc_hd__decap_12
XFILLER_0_47_1323 VPWR VGND VPWR VGND sky130_ef_sc_hd__decap_12
XFILLER_0_71_593 VPWR VGND VPWR VGND sky130_ef_sc_hd__decap_12
XFILLER_0_82_1225 VGND VGND VPWR VPWR sky130_fd_sc_hd__fill_1
XFILLER_0_114_673 VPWR VGND VPWR VGND sky130_ef_sc_hd__decap_12
XFILLER_0_4_893 VPWR VGND VPWR VGND sky130_ef_sc_hd__decap_12
XFILLER_0_113_161 VGND VGND VPWR VPWR sky130_fd_sc_hd__decap_6
XFILLER_0_222_1147 VGND VGND VPWR VPWR sky130_fd_sc_hd__fill_1
XANTENNA_u_pe11_valid_in valid_10_out_11_in VGND VGND VPWR VPWR sky130_fd_sc_hd__diode_2
XFILLER_0_216_725 VPWR VGND VPWR VGND sky130_ef_sc_hd__decap_12
XFILLER_0_122_1281 VGND VGND VPWR VPWR sky130_fd_sc_hd__fill_1
Xinput126 w01[3] VGND VGND VPWR VPWR net126 sky130_fd_sc_hd__buf_4
Xinput115 w00[8] VGND VGND VPWR VPWR net115 sky130_fd_sc_hd__buf_1
Xinput104 w00[12] VGND VGND VPWR VPWR net104 sky130_fd_sc_hd__buf_1
XFILLER_0_192_1213 VPWR VGND VPWR VGND sky130_ef_sc_hd__decap_12
XFILLER_0_216_769 VPWR VGND VPWR VGND sky130_ef_sc_hd__decap_12
Xinput137 w10[13] VGND VGND VPWR VPWR net137 sky130_fd_sc_hd__clkbuf_4
Xinput148 w10[9] VGND VGND VPWR VPWR net148 sky130_fd_sc_hd__clkbuf_4
XFILLER_0_157_1311 VPWR VGND VPWR VGND sky130_ef_sc_hd__decap_12
Xinput159 w11[4] VGND VGND VPWR VPWR net159 sky130_fd_sc_hd__buf_4
XFILLER_0_215_279 VGND VGND VPWR VPWR sky130_fd_sc_hd__fill_1
XFILLER_0_118_1339 VGND VGND VPWR VPWR sky130_fd_sc_hd__decap_4
XFILLER_0_93_1343 VGND VGND VPWR VPWR sky130_fd_sc_hd__fill_1
XFILLER_0_196_643 VPWR VGND VPWR VGND sky130_ef_sc_hd__decap_12
XFILLER_0_224_13 VPWR VGND VPWR VGND sky130_ef_sc_hd__decap_12
XFILLER_0_211_441 VGND VGND VPWR VPWR sky130_fd_sc_hd__decap_6
XANTENNA_u_pe00_act_in[12] net4 VGND VGND VPWR VPWR sky130_fd_sc_hd__diode_2
XFILLER_0_86_619 VPWR VGND VPWR VGND sky130_ef_sc_hd__decap_12
XFILLER_0_211_485 VPWR VGND VPWR VGND sky130_ef_sc_hd__decap_12
XFILLER_0_6_1147 VGND VGND VPWR VPWR sky130_fd_sc_hd__fill_1
XPHY_143 VGND VGND VPWR VPWR sky130_fd_sc_hd__decap_3
XPHY_121 VGND VGND VPWR VPWR sky130_fd_sc_hd__decap_3
XPHY_132 VGND VGND VPWR VPWR sky130_fd_sc_hd__decap_3
XPHY_110 VGND VGND VPWR VPWR sky130_fd_sc_hd__decap_3
XPHY_154 VGND VGND VPWR VPWR sky130_fd_sc_hd__decap_3
XPHY_165 VGND VGND VPWR VPWR sky130_fd_sc_hd__decap_3
XPHY_176 VGND VGND VPWR VPWR sky130_fd_sc_hd__decap_3
XANTENNA_input99_A valid_row0_in VGND VGND VPWR VPWR sky130_fd_sc_hd__diode_2
XPHY_187 VGND VGND VPWR VPWR sky130_fd_sc_hd__decap_3
XPHY_198 VGND VGND VPWR VPWR sky130_fd_sc_hd__decap_3
XFILLER_0_164_1337 VGND VGND VPWR VPWR sky130_fd_sc_hd__fill_1
XFILLER_0_62_593 VPWR VGND VPWR VGND sky130_ef_sc_hd__decap_12
XFILLER_0_205_1323 VPWR VGND VPWR VGND sky130_ef_sc_hd__decap_12
XFILLER_0_105_673 VPWR VGND VPWR VGND sky130_ef_sc_hd__decap_12
XFILLER_0_1_329 VGND VGND VPWR VPWR sky130_fd_sc_hd__decap_6
XFILLER_0_61_1309 VGND VGND VPWR VPWR sky130_fd_sc_hd__fill_1
XFILLER_0_120_643 VPWR VGND VPWR VGND sky130_ef_sc_hd__decap_12
XFILLER_0_10_619 VPWR VGND VPWR VGND sky130_ef_sc_hd__decap_12
XFILLER_0_219_541 VPWR VGND VPWR VGND sky130_ef_sc_hd__decap_12
XFILLER_0_219_585 VPWR VGND VPWR VGND sky130_ef_sc_hd__decap_12
XFILLER_0_94_29 VPWR VGND VPWR VGND sky130_ef_sc_hd__decap_12
XFILLER_0_59_1249 VGND VGND VPWR VPWR sky130_fd_sc_hd__decap_4
XFILLER_0_221_205 VPWR VGND VPWR VGND sky130_ef_sc_hd__decap_12
XFILLER_0_221_249 VPWR VGND VPWR VGND sky130_ef_sc_hd__decap_12
XPHY_1 VGND VGND VPWR VPWR sky130_fd_sc_hd__decap_3
XFILLER_0_85_641 VGND VGND VPWR VPWR sky130_fd_sc_hd__decap_4
XFILLER_0_223_3 VPWR VGND VPWR VGND sky130_ef_sc_hd__decap_12
XFILLER_0_169_1237 VPWR VGND VPWR VGND sky130_ef_sc_hd__decap_12
XFILLER_0_53_593 VPWR VGND VPWR VGND sky130_ef_sc_hd__decap_12
XANTENNA_u_pe00_psum_in[28] net54 VGND VGND VPWR VPWR sky130_fd_sc_hd__diode_2
XFILLER_0_4_189 VGND VGND VPWR VPWR sky130_fd_sc_hd__decap_6
XFILLER_0_1_841 VPWR VGND VPWR VGND sky130_ef_sc_hd__decap_12
XFILLER_0_68_41 VGND VGND VPWR VPWR sky130_fd_sc_hd__decap_8
XFILLER_0_111_665 VGND VGND VPWR VPWR sky130_fd_sc_hd__decap_6
XFILLER_0_81_1291 VPWR VGND VPWR VGND sky130_ef_sc_hd__decap_12
XFILLER_0_110_153 VPWR VGND VPWR VGND sky130_ef_sc_hd__decap_12
XFILLER_0_42_1275 VGND VGND VPWR VPWR sky130_fd_sc_hd__decap_6
XFILLER_0_110_197 VPWR VGND VPWR VGND sky130_ef_sc_hd__decap_12
XFILLER_0_30_3 VPWR VGND VPWR VGND sky130_ef_sc_hd__decap_12
XTAP_2508 VGND VPWR sky130_fd_sc_hd__tapvpwrvgnd_1
XTAP_2519 VGND VPWR sky130_fd_sc_hd__tapvpwrvgnd_1
XFILLER_0_178_643 VPWR VGND VPWR VGND sky130_ef_sc_hd__decap_12
XTAP_1807 VGND VPWR sky130_fd_sc_hd__tapvpwrvgnd_1
XFILLER_0_68_619 VPWR VGND VPWR VGND sky130_ef_sc_hd__decap_12
XFILLER_0_221_783 VGND VGND VPWR VPWR sky130_fd_sc_hd__fill_1
XFILLER_0_152_1263 VPWR VGND VPWR VGND sky130_ef_sc_hd__decap_12
XTAP_1818 VGND VPWR sky130_fd_sc_hd__tapvpwrvgnd_1
XTAP_1829 VGND VPWR sky130_fd_sc_hd__tapvpwrvgnd_1
XFILLER_0_113_1225 VGND VGND VPWR VPWR sky130_fd_sc_hd__decap_6
XFILLER_0_113_1269 VPWR VGND VPWR VGND sky130_ef_sc_hd__decap_12
XFILLER_0_1_1033 VPWR VGND VPWR VGND sky130_ef_sc_hd__decap_12
XFILLER_0_1_1077 VPWR VGND VPWR VGND sky130_ef_sc_hd__decap_12
XFILLER_0_44_593 VPWR VGND VPWR VGND sky130_ef_sc_hd__decap_12
XFILLER_0_107_1007 VGND VGND VPWR VPWR sky130_fd_sc_hd__fill_1
XFILLER_0_124_1343 VGND VGND VPWR VPWR sky130_fd_sc_hd__fill_1
XFILLER_0_102_643 VPWR VGND VPWR VGND sky130_ef_sc_hd__decap_12
XFILLER_0_60_1331 VGND VGND VPWR VPWR sky130_fd_sc_hd__decap_6
XANTENNA_input153_A w11[13] VGND VGND VPWR VPWR sky130_fd_sc_hd__diode_2
XFILLER_0_219_57 VPWR VGND VPWR VGND sky130_ef_sc_hd__decap_12
XFILLER_0_200_1275 VGND VGND VPWR VPWR sky130_fd_sc_hd__decap_6
XFILLER_0_194_1319 VPWR VGND VPWR VGND sky130_ef_sc_hd__decap_12
XFILLER_0_216_533 VPWR VGND VPWR VGND sky130_ef_sc_hd__decap_12
XANTENNA_input14_A act_row0_in[7] VGND VGND VPWR VPWR sky130_fd_sc_hd__diode_2
XFILLER_0_131_1303 VGND VGND VPWR VPWR sky130_fd_sc_hd__decap_6
XFILLER_0_19_1255 VPWR VGND VPWR VGND sky130_ef_sc_hd__decap_12
XFILLER_0_211_293 VPWR VGND VPWR VGND sky130_ef_sc_hd__decap_12
XFILLER_0_67_641 VGND VGND VPWR VPWR sky130_fd_sc_hd__decap_4
XFILLER_0_104_27 VGND VGND VPWR VPWR sky130_fd_sc_hd__fill_1
XFILLER_0_13_47 VGND VGND VPWR VPWR sky130_fd_sc_hd__decap_3
XFILLER_0_82_655 VGND VGND VPWR VPWR sky130_fd_sc_hd__decap_4
XFILLER_0_120_15 VPWR VGND VPWR VGND sky130_ef_sc_hd__decap_12
XFILLER_0_168_1281 VGND VGND VPWR VPWR sky130_fd_sc_hd__fill_1
XFILLER_0_35_593 VPWR VGND VPWR VGND sky130_ef_sc_hd__decap_12
XFILLER_0_106_993 VPWR VGND VPWR VGND sky130_ef_sc_hd__decap_12
XFILLER_0_65_1253 VGND VGND VPWR VPWR sky130_fd_sc_hd__fill_1
XFILLER_0_1_137 VPWR VGND VPWR VGND sky130_ef_sc_hd__decap_12
XFILLER_0_129_46 VGND VGND VPWR VPWR sky130_fd_sc_hd__fill_2
XFILLER_0_219_393 VPWR VGND VPWR VGND sky130_ef_sc_hd__decap_12
XFILLER_0_173_3 VPWR VGND VPWR VGND sky130_ef_sc_hd__decap_12
XFILLER_0_222_525 VGND VGND VPWR VPWR sky130_fd_sc_hd__decap_6
XFILLER_0_136_1225 VGND VGND VPWR VPWR sky130_fd_sc_hd__fill_1
XFILLER_0_222_569 VPWR VGND VPWR VGND sky130_ef_sc_hd__decap_12
XFILLER_0_37_1311 VPWR VGND VPWR VGND sky130_ef_sc_hd__decap_12
XFILLER_0_72_1213 VPWR VGND VPWR VGND sky130_ef_sc_hd__decap_12
XFILLER_0_161_22 VPWR VGND VPWR VGND sky130_ef_sc_hd__decap_12
XFILLER_0_190_605 VPWR VGND VPWR VGND sky130_ef_sc_hd__decap_12
XFILLER_0_73_655 VGND VGND VPWR VPWR sky130_fd_sc_hd__fill_2
XFILLER_0_182_1201 VPWR VGND VPWR VGND sky130_ef_sc_hd__decap_12
XFILLER_0_147_1343 VGND VGND VPWR VPWR sky130_fd_sc_hd__fill_1
XFILLER_0_26_593 VPWR VGND VPWR VGND sky130_ef_sc_hd__decap_12
XANTENNA_u_pe11_weight_in[13] net153 VGND VGND VPWR VPWR sky130_fd_sc_hd__diode_2
XFILLER_0_78_3 VPWR VGND VPWR VGND sky130_ef_sc_hd__decap_12
XFILLER_0_223_1231 VGND VGND VPWR VPWR sky130_fd_sc_hd__fill_1
XANTENNA_u_pe01_psum_in[27] net85 VGND VGND VPWR VPWR sky130_fd_sc_hd__diode_2
XFILLER_0_44_1337 VGND VGND VPWR VPWR sky130_fd_sc_hd__fill_1
XFILLER_0_1_671 VGND VGND VPWR VPWR sky130_fd_sc_hd__fill_1
XFILLER_0_111_473 VPWR VGND VPWR VGND sky130_ef_sc_hd__decap_12
XFILLER_0_186_41 VGND VGND VPWR VPWR sky130_fd_sc_hd__decap_8
XFILLER_0_106_1073 VPWR VGND VPWR VGND sky130_ef_sc_hd__decap_12
XFILLER_0_226_820 VPWR VGND VPWR VGND sky130_ef_sc_hd__decap_12
XANTENNA_input6_A act_row0_in[14] VGND VGND VPWR VPWR sky130_fd_sc_hd__diode_2
XFILLER_0_226_864 VGND VGND VPWR VPWR sky130_fd_sc_hd__decap_4
XFILLER_0_226_897 VGND VGND VPWR VPWR sky130_fd_sc_hd__decap_6
XFILLER_0_226_886 VGND VGND VPWR VPWR sky130_fd_sc_hd__decap_8
XFILLER_0_213_503 VGND VGND VPWR VPWR sky130_fd_sc_hd__fill_1
XFILLER_0_225_385 VGND VGND VPWR VPWR sky130_fd_sc_hd__decap_6
XFILLER_0_217_1057 VGND VGND VPWR VPWR sky130_fd_sc_hd__decap_6
XTAP_2316 VGND VPWR sky130_fd_sc_hd__tapvpwrvgnd_1
XFILLER_0_115_1309 VGND VGND VPWR VPWR sky130_fd_sc_hd__fill_1
XTAP_2305 VGND VPWR sky130_fd_sc_hd__tapvpwrvgnd_1
XFILLER_0_205_15 VPWR VGND VPWR VGND sky130_ef_sc_hd__decap_12
XTAP_2349 VGND VPWR sky130_fd_sc_hd__tapvpwrvgnd_1
XTAP_2327 VGND VPWR sky130_fd_sc_hd__tapvpwrvgnd_1
XTAP_2338 VGND VPWR sky130_fd_sc_hd__tapvpwrvgnd_1
XTAP_1604 VGND VPWR sky130_fd_sc_hd__tapvpwrvgnd_1
XTAP_1615 VGND VPWR sky130_fd_sc_hd__tapvpwrvgnd_1
XTAP_1637 VGND VPWR sky130_fd_sc_hd__tapvpwrvgnd_1
XFILLER_0_49_641 VGND VGND VPWR VPWR sky130_fd_sc_hd__decap_4
XTAP_1626 VGND VPWR sky130_fd_sc_hd__tapvpwrvgnd_1
XTAP_1648 VGND VPWR sky130_fd_sc_hd__tapvpwrvgnd_1
XFILLER_0_113_1033 VPWR VGND VPWR VGND sky130_ef_sc_hd__decap_12
XTAP_1659 VGND VPWR sky130_fd_sc_hd__tapvpwrvgnd_1
XFILLER_0_181_605 VPWR VGND VPWR VGND sky130_ef_sc_hd__decap_12
XFILLER_0_113_1077 VPWR VGND VPWR VGND sky130_ef_sc_hd__decap_12
XFILLER_0_64_655 VGND VGND VPWR VPWR sky130_fd_sc_hd__decap_4
XFILLER_0_221_69 VPWR VGND VPWR VGND sky130_ef_sc_hd__decap_12
XFILLER_0_88_1275 VGND VGND VPWR VPWR sky130_fd_sc_hd__decap_6
XFILLER_0_17_593 VPWR VGND VPWR VGND sky130_ef_sc_hd__decap_12
XFILLER_0_49_1237 VPWR VGND VPWR VGND sky130_ef_sc_hd__decap_12
XFILLER_0_106_245 VGND VGND VPWR VPWR sky130_fd_sc_hd__decap_6
XFILLER_0_224_1017 VPWR VGND VPWR VGND sky130_ef_sc_hd__decap_12
XFILLER_0_106_289 VPWR VGND VPWR VGND sky130_ef_sc_hd__decap_12
XFILLER_0_202_1337 VGND VGND VPWR VPWR sky130_fd_sc_hd__fill_1
XFILLER_0_198_1263 VPWR VGND VPWR VGND sky130_ef_sc_hd__decap_12
XFILLER_0_159_1225 VPWR VGND VPWR VGND sky130_ef_sc_hd__decap_12
XFILLER_0_217_853 VPWR VGND VPWR VGND sky130_ef_sc_hd__decap_12
XFILLER_0_95_1213 VPWR VGND VPWR VGND sky130_ef_sc_hd__decap_12
XFILLER_0_217_897 VPWR VGND VPWR VGND sky130_ef_sc_hd__decap_12
XFILLER_0_216_363 VGND VGND VPWR VPWR sky130_fd_sc_hd__fill_1
XFILLER_0_95_1279 VPWR VGND VPWR VGND sky130_ef_sc_hd__decap_12
XFILLER_0_24_13 VPWR VGND VPWR VGND sky130_ef_sc_hd__decap_12
XANTENNA_output218_A net218 VGND VGND VPWR VPWR sky130_fd_sc_hd__diode_2
XFILLER_0_115_37 VPWR VGND VPWR VGND sky130_ef_sc_hd__decap_12
XTAP_2872 VGND VPWR sky130_fd_sc_hd__tapvpwrvgnd_1
XTAP_2861 VGND VPWR sky130_fd_sc_hd__tapvpwrvgnd_1
XTAP_2850 VGND VPWR sky130_fd_sc_hd__tapvpwrvgnd_1
XTAP_2894 VGND VPWR sky130_fd_sc_hd__tapvpwrvgnd_1
XTAP_2883 VGND VPWR sky130_fd_sc_hd__tapvpwrvgnd_1
XFILLER_0_135_1291 VPWR VGND VPWR VGND sky130_ef_sc_hd__decap_12
XFILLER_0_172_605 VPWR VGND VPWR VGND sky130_ef_sc_hd__decap_12
XFILLER_0_32_1263 VPWR VGND VPWR VGND sky130_ef_sc_hd__decap_12
XFILLER_0_55_655 VGND VGND VPWR VPWR sky130_fd_sc_hd__fill_2
XFILLER_0_131_47 VGND VGND VPWR VPWR sky130_fd_sc_hd__fill_1
XFILLER_0_207_1237 VPWR VGND VPWR VGND sky130_ef_sc_hd__decap_12
XFILLER_0_113_727 VGND VGND VPWR VPWR sky130_fd_sc_hd__fill_1
XFILLER_0_2_413 VGND VGND VPWR VPWR sky130_fd_sc_hd__decap_6
XFILLER_0_2_457 VPWR VGND VPWR VGND sky130_ef_sc_hd__decap_12
Xoutput205 net205 VGND VGND VPWR VPWR psum_col1_out[17] sky130_fd_sc_hd__clkbuf_4
Xoutput216 net216 VGND VGND VPWR VPWR psum_col1_out[27] sky130_fd_sc_hd__clkbuf_4
XFILLER_0_142_1251 VPWR VGND VPWR VGND sky130_ef_sc_hd__decap_12
Xoutput227 net227 VGND VGND VPWR VPWR psum_col1_out[8] sky130_fd_sc_hd__clkbuf_4
XFILLER_0_103_1213 VPWR VGND VPWR VGND sky130_ef_sc_hd__decap_12
XFILLER_0_177_1303 VGND VGND VPWR VPWR sky130_fd_sc_hd__decap_6
XFILLER_0_226_138 VGND VGND VPWR VPWR sky130_fd_sc_hd__fill_2
XFILLER_0_226_116 VGND VGND VPWR VPWR sky130_fd_sc_hd__fill_2
XFILLER_0_142_1295 VPWR VGND VPWR VGND sky130_ef_sc_hd__decap_12
XFILLER_0_103_1279 VPWR VGND VPWR VGND sky130_ef_sc_hd__decap_12
XFILLER_0_222_333 VPWR VGND VPWR VGND sky130_ef_sc_hd__decap_12
XFILLER_0_74_1319 VPWR VGND VPWR VGND sky130_ef_sc_hd__decap_12
XFILLER_0_223_889 VGND VGND VPWR VPWR sky130_fd_sc_hd__decap_6
XFILLER_0_222_377 VPWR VGND VPWR VGND sky130_ef_sc_hd__decap_12
XPHY_709 VGND VGND VPWR VPWR sky130_fd_sc_hd__decap_3
XFILLER_0_110_1217 VPWR VGND VPWR VGND sky130_ef_sc_hd__decap_12
XFILLER_0_163_605 VPWR VGND VPWR VGND sky130_ef_sc_hd__decap_12
XFILLER_0_11_1303 VGND VGND VPWR VPWR sky130_fd_sc_hd__decap_6
XFILLER_0_105_81 VPWR VGND VPWR VGND sky130_ef_sc_hd__decap_12
XFILLER_0_184_1307 VPWR VGND VPWR VGND sky130_ef_sc_hd__decap_12
XFILLER_0_46_655 VGND VGND VPWR VPWR sky130_fd_sc_hd__decap_4
XFILLER_0_2_1161 VPWR VGND VPWR VGND sky130_ef_sc_hd__decap_12
XFILLER_0_5_273 VGND VGND VPWR VPWR sky130_fd_sc_hd__decap_6
XFILLER_0_61_647 VGND VGND VPWR VPWR sky130_fd_sc_hd__decap_8
XFILLER_0_225_1337 VGND VGND VPWR VPWR sky130_fd_sc_hd__fill_1
XFILLER_0_48_1281 VGND VGND VPWR VPWR sky130_fd_sc_hd__fill_1
XFILLER_0_112_793 VPWR VGND VPWR VGND sky130_ef_sc_hd__decap_12
XFILLER_0_111_281 VPWR VGND VPWR VGND sky130_ef_sc_hd__decap_12
XFILLER_0_217_105 VGND VGND VPWR VPWR sky130_fd_sc_hd__decap_6
XFILLER_0_121_1335 VGND VGND VPWR VPWR sky130_fd_sc_hd__decap_8
XFILLER_0_219_1119 VGND VGND VPWR VPWR sky130_fd_sc_hd__fill_1
XFILLER_0_217_149 VPWR VGND VPWR VGND sky130_ef_sc_hd__decap_12
XFILLER_0_214_867 VGND VGND VPWR VPWR sky130_fd_sc_hd__fill_1
XFILLER_0_225_193 VPWR VGND VPWR VGND sky130_ef_sc_hd__decap_12
XFILLER_0_119_1253 VGND VGND VPWR VPWR sky130_fd_sc_hd__fill_1
XTAP_2135 VGND VPWR sky130_fd_sc_hd__tapvpwrvgnd_1
XTAP_2124 VGND VPWR sky130_fd_sc_hd__tapvpwrvgnd_1
XTAP_2113 VGND VPWR sky130_fd_sc_hd__tapvpwrvgnd_1
XTAP_2102 VGND VPWR sky130_fd_sc_hd__tapvpwrvgnd_1
XTAP_2168 VGND VPWR sky130_fd_sc_hd__tapvpwrvgnd_1
XTAP_2157 VGND VPWR sky130_fd_sc_hd__tapvpwrvgnd_1
XTAP_2146 VGND VPWR sky130_fd_sc_hd__tapvpwrvgnd_1
XTAP_1412 VGND VPWR sky130_fd_sc_hd__tapvpwrvgnd_1
XTAP_1423 VGND VPWR sky130_fd_sc_hd__tapvpwrvgnd_1
XTAP_1401 VGND VPWR sky130_fd_sc_hd__tapvpwrvgnd_1
XFILLER_0_16_1225 VGND VGND VPWR VPWR sky130_fd_sc_hd__fill_1
XANTENNA_input116_A w00[9] VGND VGND VPWR VPWR sky130_fd_sc_hd__diode_2
XTAP_2179 VGND VPWR sky130_fd_sc_hd__tapvpwrvgnd_1
XTAP_1434 VGND VPWR sky130_fd_sc_hd__tapvpwrvgnd_1
XFILLER_0_7_1061 VGND VGND VPWR VPWR sky130_fd_sc_hd__decap_3
XTAP_1445 VGND VPWR sky130_fd_sc_hd__tapvpwrvgnd_1
XTAP_1456 VGND VPWR sky130_fd_sc_hd__tapvpwrvgnd_1
XFILLER_0_154_605 VPWR VGND VPWR VGND sky130_ef_sc_hd__decap_12
XTAP_1478 VGND VPWR sky130_fd_sc_hd__tapvpwrvgnd_1
XTAP_1467 VGND VPWR sky130_fd_sc_hd__tapvpwrvgnd_1
XTAP_1489 VGND VPWR sky130_fd_sc_hd__tapvpwrvgnd_1
XFILLER_0_37_655 VGND VGND VPWR VPWR sky130_fd_sc_hd__fill_2
XANTENNA_input81_A psum_col1_in[23] VGND VGND VPWR VPWR sky130_fd_sc_hd__diode_2
XFILLER_0_126_1213 VPWR VGND VPWR VGND sky130_ef_sc_hd__decap_12
XFILLER_0_62_1201 VPWR VGND VPWR VGND sky130_ef_sc_hd__decap_12
XFILLER_0_27_1343 VGND VGND VPWR VPWR sky130_fd_sc_hd__fill_1
XFILLER_0_206_1281 VGND VGND VPWR VPWR sky130_fd_sc_hd__fill_1
XFILLER_0_209_617 VPWR VGND VPWR VGND sky130_ef_sc_hd__decap_12
XFILLER_0_35_45 VGND VGND VPWR VPWR sky130_fd_sc_hd__decap_3
XFILLER_0_220_837 VPWR VGND VPWR VGND sky130_ef_sc_hd__decap_12
XTAP_2680 VGND VPWR sky130_fd_sc_hd__tapvpwrvgnd_1
XTAP_2691 VGND VPWR sky130_fd_sc_hd__tapvpwrvgnd_1
XFILLER_0_145_605 VPWR VGND VPWR VGND sky130_ef_sc_hd__decap_12
XFILLER_0_7_505 VPWR VGND VPWR VGND sky130_ef_sc_hd__decap_12
XTAP_1990 VGND VPWR sky130_fd_sc_hd__tapvpwrvgnd_1
XFILLER_0_28_655 VGND VGND VPWR VPWR sky130_fd_sc_hd__decap_4
XFILLER_0_160_619 VPWR VGND VPWR VGND sky130_ef_sc_hd__decap_12
XFILLER_0_43_647 VGND VGND VPWR VPWR sky130_fd_sc_hd__decap_8
XFILLER_0_2_221 VPWR VGND VPWR VGND sky130_ef_sc_hd__decap_12
XFILLER_0_3_777 VGND VGND VPWR VPWR sky130_fd_sc_hd__decap_6
XFILLER_0_2_265 VPWR VGND VPWR VGND sky130_ef_sc_hd__decap_12
XFILLER_0_76_41 VGND VGND VPWR VPWR sky130_fd_sc_hd__decap_8
XFILLER_0_215_609 VGND VGND VPWR VPWR sky130_fd_sc_hd__decap_6
XFILLER_0_218_1141 VGND VGND VPWR VPWR sky130_fd_sc_hd__decap_6
XFILLER_0_39_1225 VPWR VGND VPWR VGND sky130_ef_sc_hd__decap_12
XFILLER_0_78_1263 VPWR VGND VPWR VGND sky130_ef_sc_hd__decap_12
XFILLER_0_214_1005 VPWR VGND VPWR VGND sky130_ef_sc_hd__decap_12
XFILLER_0_223_653 VPWR VGND VPWR VGND sky130_ef_sc_hd__decap_12
XFILLER_0_222_141 VPWR VGND VPWR VGND sky130_ef_sc_hd__decap_12
XFILLER_0_218_1185 VPWR VGND VPWR VGND sky130_ef_sc_hd__decap_12
XFILLER_0_214_1049 VPWR VGND VPWR VGND sky130_ef_sc_hd__decap_12
XFILLER_0_223_697 VPWR VGND VPWR VGND sky130_ef_sc_hd__decap_12
XPHY_506 VGND VGND VPWR VPWR sky130_fd_sc_hd__decap_3
XPHY_517 VGND VGND VPWR VPWR sky130_fd_sc_hd__decap_3
XPHY_1105 VGND VGND VPWR VPWR sky130_fd_sc_hd__decap_3
XFILLER_0_114_1161 VPWR VGND VPWR VGND sky130_ef_sc_hd__decap_12
XFILLER_0_136_605 VPWR VGND VPWR VGND sky130_ef_sc_hd__decap_12
XPHY_528 VGND VGND VPWR VPWR sky130_fd_sc_hd__decap_3
XPHY_539 VGND VGND VPWR VPWR sky130_fd_sc_hd__decap_3
XFILLER_0_108_307 VGND VGND VPWR VPWR sky130_fd_sc_hd__fill_1
XPHY_1116 VGND VGND VPWR VPWR sky130_fd_sc_hd__decap_3
XFILLER_0_188_1251 VPWR VGND VPWR VGND sky130_ef_sc_hd__decap_12
XPHY_1138 VGND VGND VPWR VPWR sky130_fd_sc_hd__decap_3
XPHY_1127 VGND VGND VPWR VPWR sky130_fd_sc_hd__decap_3
XFILLER_0_149_1213 VPWR VGND VPWR VGND sky130_ef_sc_hd__decap_12
XFILLER_0_0_1109 VGND VGND VPWR VPWR sky130_fd_sc_hd__decap_8
XFILLER_0_15_1291 VPWR VGND VPWR VGND sky130_ef_sc_hd__decap_12
XFILLER_0_188_1295 VPWR VGND VPWR VGND sky130_ef_sc_hd__decap_12
XPHY_1149 VGND VGND VPWR VPWR sky130_fd_sc_hd__decap_3
XFILLER_0_202_49 VGND VGND VPWR VPWR sky130_fd_sc_hd__fill_1
XFILLER_0_202_27 VGND VGND VPWR VPWR sky130_fd_sc_hd__fill_1
XFILLER_0_85_1201 VPWR VGND VPWR VGND sky130_ef_sc_hd__decap_12
XFILLER_0_225_1101 VPWR VGND VPWR VGND sky130_ef_sc_hd__decap_12
XFILLER_0_149_1279 VPWR VGND VPWR VGND sky130_ef_sc_hd__decap_12
XFILLER_0_225_1145 VPWR VGND VPWR VGND sky130_ef_sc_hd__decap_12
XFILLER_0_85_1267 VPWR VGND VPWR VGND sky130_ef_sc_hd__decap_12
XFILLER_0_221_1009 VPWR VGND VPWR VGND sky130_ef_sc_hd__decap_12
XFILLER_0_104_557 VGND VGND VPWR VPWR sky130_fd_sc_hd__decap_3
XFILLER_0_225_1189 VPWR VGND VPWR VGND sky130_ef_sc_hd__decap_12
XFILLER_0_218_469 VGND VGND VPWR VPWR sky130_fd_sc_hd__decap_6
XFILLER_0_22_1251 VPWR VGND VPWR VGND sky130_ef_sc_hd__decap_12
XFILLER_0_195_1255 VPWR VGND VPWR VGND sky130_ef_sc_hd__decap_12
XFILLER_0_156_1239 VPWR VGND VPWR VGND sky130_ef_sc_hd__decap_12
XFILLER_0_22_1295 VPWR VGND VPWR VGND sky130_ef_sc_hd__decap_12
XFILLER_0_57_1303 VGND VGND VPWR VPWR sky130_fd_sc_hd__decap_6
XFILLER_0_92_1227 VPWR VGND VPWR VGND sky130_ef_sc_hd__decap_12
XTAP_1220 VGND VPWR sky130_fd_sc_hd__tapvpwrvgnd_1
XTAP_1231 VGND VPWR sky130_fd_sc_hd__tapvpwrvgnd_1
XFILLER_0_5_1009 VPWR VGND VPWR VGND sky130_ef_sc_hd__decap_12
XFILLER_0_210_892 VGND VGND VPWR VPWR sky130_fd_sc_hd__fill_1
XFILLER_0_127_605 VPWR VGND VPWR VGND sky130_ef_sc_hd__decap_12
XTAP_1242 VGND VPWR sky130_fd_sc_hd__tapvpwrvgnd_1
XTAP_1275 VGND VPWR sky130_fd_sc_hd__tapvpwrvgnd_1
XTAP_1253 VGND VPWR sky130_fd_sc_hd__tapvpwrvgnd_1
XTAP_1264 VGND VPWR sky130_fd_sc_hd__tapvpwrvgnd_1
XFILLER_0_194_593 VPWR VGND VPWR VGND sky130_ef_sc_hd__decap_12
XFILLER_0_132_1283 VPWR VGND VPWR VGND sky130_ef_sc_hd__decap_12
XTAP_1297 VGND VPWR sky130_fd_sc_hd__tapvpwrvgnd_1
XTAP_1286 VGND VPWR sky130_fd_sc_hd__tapvpwrvgnd_1
XFILLER_0_167_1335 VGND VGND VPWR VPWR sky130_fd_sc_hd__fill_1
XFILLER_0_21_25 VPWR VGND VPWR VGND sky130_ef_sc_hd__decap_12
XFILLER_0_128_1319 VPWR VGND VPWR VGND sky130_ef_sc_hd__decap_12
XFILLER_0_142_619 VPWR VGND VPWR VGND sky130_ef_sc_hd__decap_12
XFILLER_0_25_647 VGND VGND VPWR VPWR sky130_fd_sc_hd__decap_8
XFILLER_0_107_373 VPWR VGND VPWR VGND sky130_ef_sc_hd__decap_12
XFILLER_0_40_617 VGND VGND VPWR VPWR sky130_fd_sc_hd__fill_1
XFILLER_0_64_1307 VPWR VGND VPWR VGND sky130_ef_sc_hd__decap_12
XFILLER_0_0_747 VGND VGND VPWR VPWR sky130_fd_sc_hd__decap_8
XFILLER_0_0_725 VGND VGND VPWR VPWR sky130_fd_sc_hd__decap_3
XFILLER_0_104_1341 VGND VGND VPWR VPWR sky130_fd_sc_hd__decap_3
XANTENNA_u_pe10_weight_in[3] net142 VGND VGND VPWR VPWR sky130_fd_sc_hd__diode_2
XFILLER_0_218_981 VPWR VGND VPWR VGND sky130_ef_sc_hd__decap_12
XFILLER_0_100_1227 VPWR VGND VPWR VGND sky130_ef_sc_hd__decap_12
XFILLER_0_174_1339 VGND VGND VPWR VPWR sky130_fd_sc_hd__decap_4
XFILLER_0_220_601 VPWR VGND VPWR VGND sky130_ef_sc_hd__decap_12
XFILLER_0_1_13 VPWR VGND VPWR VGND sky130_ef_sc_hd__decap_12
XFILLER_0_215_1325 VGND VGND VPWR VPWR sky130_fd_sc_hd__decap_8
XFILLER_0_220_645 VPWR VGND VPWR VGND sky130_ef_sc_hd__decap_12
XFILLER_0_1_57 VPWR VGND VPWR VGND sky130_ef_sc_hd__decap_12
XFILLER_0_111_1301 VPWR VGND VPWR VGND sky130_ef_sc_hd__decap_12
XFILLER_0_118_605 VPWR VGND VPWR VGND sky130_ef_sc_hd__decap_12
XFILLER_0_185_593 VPWR VGND VPWR VGND sky130_ef_sc_hd__decap_12
XFILLER_0_31_617 VPWR VGND VPWR VGND sky130_ef_sc_hd__decap_12
XFILLER_0_141_641 VGND VGND VPWR VPWR sky130_fd_sc_hd__decap_4
XFILLER_0_3_541 VPWR VGND VPWR VGND sky130_ef_sc_hd__decap_12
XFILLER_0_222_1329 VPWR VGND VPWR VGND sky130_ef_sc_hd__decap_12
XFILLER_0_3_585 VPWR VGND VPWR VGND sky130_ef_sc_hd__decap_12
XFILLER_0_60_3 VPWR VGND VPWR VGND sky130_ef_sc_hd__decap_12
XFILLER_0_215_417 VPWR VGND VPWR VGND sky130_ef_sc_hd__decap_12
XFILLER_0_194_41 VGND VGND VPWR VPWR sky130_fd_sc_hd__decap_8
XFILLER_0_224_973 VGND VGND VPWR VPWR sky130_fd_sc_hd__decap_6
XFILLER_0_223_461 VPWR VGND VPWR VGND sky130_ef_sc_hd__decap_12
XFILLER_0_98_617 VGND VGND VPWR VPWR sky130_fd_sc_hd__fill_1
XFILLER_0_116_1201 VPWR VGND VPWR VGND sky130_ef_sc_hd__decap_12
XFILLER_0_210_133 VGND VGND VPWR VPWR sky130_fd_sc_hd__fill_1
XFILLER_0_6_1329 VPWR VGND VPWR VGND sky130_ef_sc_hd__decap_12
XPHY_325 VGND VGND VPWR VPWR sky130_fd_sc_hd__decap_3
XPHY_303 VGND VGND VPWR VPWR sky130_fd_sc_hd__decap_3
XPHY_314 VGND VGND VPWR VPWR sky130_fd_sc_hd__decap_3
XFILLER_0_176_593 VPWR VGND VPWR VGND sky130_ef_sc_hd__decap_12
XFILLER_0_213_37 VPWR VGND VPWR VGND sky130_ef_sc_hd__decap_12
XPHY_358 VGND VGND VPWR VPWR sky130_fd_sc_hd__decap_3
XPHY_347 VGND VGND VPWR VPWR sky130_fd_sc_hd__decap_3
XPHY_336 VGND VGND VPWR VPWR sky130_fd_sc_hd__decap_3
XPHY_369 VGND VGND VPWR VPWR sky130_fd_sc_hd__decap_3
XFILLER_0_124_619 VPWR VGND VPWR VGND sky130_ef_sc_hd__decap_12
XFILLER_0_105_833 VGND VGND VPWR VPWR sky130_fd_sc_hd__decap_6
XFILLER_0_22_617 VGND VGND VPWR VPWR sky130_fd_sc_hd__fill_1
XFILLER_0_104_321 VPWR VGND VPWR VGND sky130_ef_sc_hd__decap_12
XFILLER_0_105_877 VPWR VGND VPWR VGND sky130_ef_sc_hd__decap_12
XFILLER_0_123_1249 VGND VGND VPWR VPWR sky130_fd_sc_hd__decap_4
XANTENNA_input44_A psum_col0_in[19] VGND VGND VPWR VPWR sky130_fd_sc_hd__diode_2
XFILLER_0_218_233 VPWR VGND VPWR VGND sky130_ef_sc_hd__decap_12
XFILLER_0_218_277 VPWR VGND VPWR VGND sky130_ef_sc_hd__decap_12
XFILLER_0_100_593 VPWR VGND VPWR VGND sky130_ef_sc_hd__decap_12
XFILLER_0_215_951 VGND VGND VPWR VPWR sky130_fd_sc_hd__fill_1
XFILLER_0_199_641 VGND VGND VPWR VPWR sky130_fd_sc_hd__decap_4
XFILLER_0_107_27 VPWR VGND VPWR VGND sky130_ef_sc_hd__decap_12
XFILLER_0_89_617 VPWR VGND VPWR VGND sky130_ef_sc_hd__decap_12
XFILLER_0_123_15 VPWR VGND VPWR VGND sky130_ef_sc_hd__decap_12
XFILLER_0_210_1233 VPWR VGND VPWR VGND sky130_ef_sc_hd__decap_12
XFILLER_0_167_593 VPWR VGND VPWR VGND sky130_ef_sc_hd__decap_12
XPHY_870 VGND VGND VPWR VPWR sky130_fd_sc_hd__decap_3
XPHY_881 VGND VGND VPWR VPWR sky130_fd_sc_hd__decap_3
XPHY_892 VGND VGND VPWR VPWR sky130_fd_sc_hd__decap_3
XFILLER_0_5_839 VGND VGND VPWR VPWR sky130_fd_sc_hd__fill_1
XFILLER_0_108_693 VGND VGND VPWR VPWR sky130_fd_sc_hd__decap_6
XFILLER_0_13_617 VPWR VGND VPWR VGND sky130_ef_sc_hd__decap_12
XFILLER_0_29_1213 VPWR VGND VPWR VGND sky130_ef_sc_hd__decap_12
XFILLER_0_68_1251 VPWR VGND VPWR VGND sky130_ef_sc_hd__decap_12
XFILLER_0_107_181 VPWR VGND VPWR VGND sky130_ef_sc_hd__decap_12
XFILLER_0_123_641 VGND VGND VPWR VPWR sky130_fd_sc_hd__decap_4
XFILLER_0_68_1295 VPWR VGND VPWR VGND sky130_ef_sc_hd__decap_12
XFILLER_0_180_1343 VGND VGND VPWR VPWR sky130_fd_sc_hd__fill_1
XFILLER_0_29_1279 VPWR VGND VPWR VGND sky130_ef_sc_hd__decap_12
XFILLER_0_110_357 VGND VGND VPWR VPWR sky130_fd_sc_hd__decap_6
XFILLER_0_139_1201 VPWR VGND VPWR VGND sky130_ef_sc_hd__decap_12
XFILLER_0_178_1283 VPWR VGND VPWR VGND sky130_ef_sc_hd__decap_12
XFILLER_0_139_1267 VPWR VGND VPWR VGND sky130_ef_sc_hd__decap_12
XFILLER_0_164_22 VGND VGND VPWR VPWR sky130_fd_sc_hd__decap_6
XFILLER_0_221_921 VPWR VGND VPWR VGND sky130_ef_sc_hd__decap_12
XFILLER_0_75_1255 VPWR VGND VPWR VGND sky130_ef_sc_hd__decap_12
XFILLER_0_215_1133 VPWR VGND VPWR VGND sky130_ef_sc_hd__decap_12
XFILLER_0_221_965 VPWR VGND VPWR VGND sky130_ef_sc_hd__decap_12
XFILLER_0_36_1239 VPWR VGND VPWR VGND sky130_ef_sc_hd__decap_12
XFILLER_0_215_1177 VPWR VGND VPWR VGND sky130_ef_sc_hd__decap_12
XFILLER_0_220_475 VGND VGND VPWR VPWR sky130_fd_sc_hd__fill_1
XFILLER_0_158_593 VPWR VGND VPWR VGND sky130_ef_sc_hd__decap_12
XFILLER_0_8_655 VGND VGND VPWR VPWR sky130_fd_sc_hd__decap_4
XFILLER_0_111_1175 VGND VGND VPWR VPWR sky130_fd_sc_hd__fill_1
XFILLER_0_7_165 VGND VGND VPWR VPWR sky130_fd_sc_hd__decap_3
XFILLER_0_113_81 VPWR VGND VPWR VGND sky130_ef_sc_hd__decap_12
XFILLER_0_146_1227 VPWR VGND VPWR VGND sky130_ef_sc_hd__decap_12
XFILLER_0_12_1283 VPWR VGND VPWR VGND sky130_ef_sc_hd__decap_12
XFILLER_0_114_641 VGND VGND VPWR VPWR sky130_fd_sc_hd__decap_3
XFILLER_0_4_861 VGND VGND VPWR VPWR sky130_fd_sc_hd__decap_6
XFILLER_0_47_1335 VGND VGND VPWR VPWR sky130_fd_sc_hd__fill_1
XFILLER_0_114_685 VPWR VGND VPWR VGND sky130_ef_sc_hd__decap_12
XFILLER_0_3_393 VPWR VGND VPWR VGND sky130_ef_sc_hd__decap_12
XFILLER_0_208_15 VPWR VGND VPWR VGND sky130_ef_sc_hd__decap_12
Xinput127 w01[4] VGND VGND VPWR VPWR net127 sky130_fd_sc_hd__buf_4
Xinput116 w00[9] VGND VGND VPWR VPWR net116 sky130_fd_sc_hd__buf_1
Xinput105 w00[13] VGND VGND VPWR VPWR net105 sky130_fd_sc_hd__buf_1
XFILLER_0_216_737 VPWR VGND VPWR VGND sky130_ef_sc_hd__decap_12
Xinput138 w10[14] VGND VGND VPWR VPWR net138 sky130_fd_sc_hd__clkbuf_4
XFILLER_0_215_225 VPWR VGND VPWR VGND sky130_ef_sc_hd__decap_12
XFILLER_0_157_1323 VPWR VGND VPWR VGND sky130_ef_sc_hd__decap_12
Xinput149 w11[0] VGND VGND VPWR VPWR net149 sky130_fd_sc_hd__buf_4
XFILLER_0_192_1225 VGND VGND VPWR VPWR sky130_fd_sc_hd__fill_1
XFILLER_0_118_1307 VPWR VGND VPWR VGND sky130_ef_sc_hd__decap_12
XFILLER_0_93_1311 VPWR VGND VPWR VGND sky130_ef_sc_hd__decap_12
XFILLER_0_224_781 VPWR VGND VPWR VGND sky130_ef_sc_hd__decap_12
XANTENNA_u_pe00_act_in[11] net3 VGND VGND VPWR VPWR sky130_fd_sc_hd__diode_2
XFILLER_0_224_25 VGND VGND VPWR VPWR sky130_fd_sc_hd__decap_3
XFILLER_0_54_1339 VGND VGND VPWR VPWR sky130_fd_sc_hd__decap_4
XFILLER_0_196_655 VGND VGND VPWR VPWR sky130_fd_sc_hd__decap_4
XPHY_100 VGND VGND VPWR VPWR sky130_fd_sc_hd__decap_3
XFILLER_0_211_497 VGND VGND VPWR VPWR sky130_fd_sc_hd__decap_6
XFILLER_0_94_631 VPWR VGND VPWR VGND sky130_ef_sc_hd__decap_12
XPHY_133 VGND VGND VPWR VPWR sky130_fd_sc_hd__decap_3
XPHY_111 VGND VGND VPWR VPWR sky130_fd_sc_hd__decap_3
XPHY_122 VGND VGND VPWR VPWR sky130_fd_sc_hd__decap_3
XFILLER_0_149_593 VPWR VGND VPWR VGND sky130_ef_sc_hd__decap_12
XPHY_166 VGND VGND VPWR VPWR sky130_fd_sc_hd__decap_3
XPHY_155 VGND VGND VPWR VPWR sky130_fd_sc_hd__decap_3
XPHY_144 VGND VGND VPWR VPWR sky130_fd_sc_hd__decap_3
XPHY_199 VGND VGND VPWR VPWR sky130_fd_sc_hd__decap_3
XPHY_177 VGND VGND VPWR VPWR sky130_fd_sc_hd__decap_3
XPHY_188 VGND VGND VPWR VPWR sky130_fd_sc_hd__decap_3
XFILLER_0_105_641 VPWR VGND VPWR VGND sky130_ef_sc_hd__decap_12
XFILLER_0_205_1335 VGND VGND VPWR VPWR sky130_fd_sc_hd__decap_8
XFILLER_0_105_685 VPWR VGND VPWR VGND sky130_ef_sc_hd__decap_12
XFILLER_0_120_655 VGND VGND VPWR VPWR sky130_fd_sc_hd__decap_4
XFILLER_0_219_553 VGND VGND VPWR VPWR sky130_fd_sc_hd__decap_6
XFILLER_0_101_1311 VPWR VGND VPWR VGND sky130_ef_sc_hd__decap_12
XFILLER_0_118_15 VPWR VGND VPWR VGND sky130_ef_sc_hd__decap_12
XFILLER_0_219_597 VPWR VGND VPWR VGND sky130_ef_sc_hd__decap_12
XFILLER_0_221_217 VGND VGND VPWR VPWR sky130_fd_sc_hd__decap_6
XFILLER_0_171_1309 VGND VGND VPWR VPWR sky130_fd_sc_hd__fill_1
XFILLER_0_168_6 VGND VGND VPWR VPWR sky130_fd_sc_hd__fill_2
XFILLER_0_212_1317 VPWR VGND VPWR VGND sky130_ef_sc_hd__decap_12
XPHY_2 VGND VGND VPWR VPWR sky130_fd_sc_hd__decap_3
XFILLER_0_210_1030 VGND VGND VPWR VPWR sky130_fd_sc_hd__decap_6
XFILLER_0_169_1249 VGND VGND VPWR VPWR sky130_fd_sc_hd__decap_4
Xclkbuf_0_clk clk VGND VGND VPWR VPWR clknet_0_clk sky130_fd_sc_hd__clkbuf_16
XFILLER_0_216_3 VPWR VGND VPWR VGND sky130_ef_sc_hd__decap_12
XANTENNA_u_pe00_psum_in[27] net53 VGND VGND VPWR VPWR sky130_fd_sc_hd__diode_2
XFILLER_0_1_853 VPWR VGND VPWR VGND sky130_ef_sc_hd__decap_12
XFILLER_0_110_121 VPWR VGND VPWR VGND sky130_ef_sc_hd__decap_12
XFILLER_0_1_897 VPWR VGND VPWR VGND sky130_ef_sc_hd__decap_12
XFILLER_0_110_165 VPWR VGND VPWR VGND sky130_ef_sc_hd__decap_12
XFILLER_0_84_41 VGND VGND VPWR VPWR sky130_fd_sc_hd__decap_8
XTAP_2509 VGND VPWR sky130_fd_sc_hd__tapvpwrvgnd_1
XFILLER_0_213_729 VPWR VGND VPWR VGND sky130_ef_sc_hd__decap_12
XFILLER_0_23_3 VPWR VGND VPWR VGND sky130_ef_sc_hd__decap_12
XFILLER_0_191_1291 VPWR VGND VPWR VGND sky130_ef_sc_hd__decap_12
XFILLER_0_178_655 VGND VGND VPWR VPWR sky130_fd_sc_hd__decap_4
XTAP_1819 VGND VPWR sky130_fd_sc_hd__tapvpwrvgnd_1
XTAP_1808 VGND VPWR sky130_fd_sc_hd__tapvpwrvgnd_1
XFILLER_0_152_1275 VGND VGND VPWR VPWR sky130_fd_sc_hd__decap_6
XFILLER_0_76_631 VPWR VGND VPWR VGND sky130_ef_sc_hd__decap_12
XFILLER_0_193_647 VPWR VGND VPWR VGND sky130_ef_sc_hd__decap_12
XFILLER_0_1_1001 VGND VGND VPWR VPWR sky130_fd_sc_hd__decap_6
XFILLER_0_91_645 VGND VGND VPWR VPWR sky130_fd_sc_hd__fill_1
XFILLER_0_1_1045 VPWR VGND VPWR VGND sky130_ef_sc_hd__decap_12
XFILLER_0_1_1089 VPWR VGND VPWR VGND sky130_ef_sc_hd__decap_12
XFILLER_0_102_655 VGND VGND VPWR VPWR sky130_fd_sc_hd__decap_4
XFILLER_0_216_501 VPWR VGND VPWR VGND sky130_ef_sc_hd__decap_12
XFILLER_0_60_1343 VGND VGND VPWR VPWR sky130_fd_sc_hd__fill_1
XFILLER_0_219_69 VPWR VGND VPWR VGND sky130_ef_sc_hd__decap_12
XANTENNA_input146_A w10[7] VGND VGND VPWR VPWR sky130_fd_sc_hd__diode_2
XFILLER_0_216_545 VPWR VGND VPWR VGND sky130_ef_sc_hd__decap_12
XFILLER_0_216_589 VPWR VGND VPWR VGND sky130_ef_sc_hd__decap_12
XFILLER_0_19_1201 VPWR VGND VPWR VGND sky130_ef_sc_hd__decap_12
XFILLER_0_58_1283 VPWR VGND VPWR VGND sky130_ef_sc_hd__decap_12
XFILLER_0_170_1331 VGND VGND VPWR VPWR sky130_fd_sc_hd__decap_6
XFILLER_0_169_655 VGND VGND VPWR VPWR sky130_fd_sc_hd__fill_2
XFILLER_0_19_1267 VPWR VGND VPWR VGND sky130_ef_sc_hd__decap_12
XFILLER_0_211_261 VPWR VGND VPWR VGND sky130_ef_sc_hd__decap_12
XFILLER_0_13_15 VPWR VGND VPWR VGND sky130_ef_sc_hd__decap_12
XFILLER_0_129_1255 VPWR VGND VPWR VGND sky130_ef_sc_hd__decap_12
XFILLER_0_113_909 VPWR VGND VPWR VGND sky130_ef_sc_hd__decap_12
XFILLER_0_106_961 VPWR VGND VPWR VGND sky130_ef_sc_hd__decap_12
XFILLER_0_120_27 VGND VGND VPWR VPWR sky130_fd_sc_hd__fill_1
XFILLER_0_1_105 VGND VGND VPWR VPWR sky130_fd_sc_hd__decap_6
XFILLER_0_112_419 VGND VGND VPWR VPWR sky130_fd_sc_hd__fill_1
XFILLER_0_120_49 VGND VGND VPWR VPWR sky130_fd_sc_hd__fill_1
XFILLER_0_1_149 VPWR VGND VPWR VGND sky130_ef_sc_hd__decap_12
XFILLER_0_26_1227 VPWR VGND VPWR VGND sky130_ef_sc_hd__decap_12
XFILLER_0_226_309 VGND VGND VPWR VPWR sky130_fd_sc_hd__fill_2
XFILLER_0_219_361 VPWR VGND VPWR VGND sky130_ef_sc_hd__decap_12
XFILLER_0_175_1253 VGND VGND VPWR VPWR sky130_fd_sc_hd__fill_1
XFILLER_0_37_1323 VPWR VGND VPWR VGND sky130_ef_sc_hd__decap_12
XFILLER_0_166_3 VPWR VGND VPWR VGND sky130_ef_sc_hd__decap_12
XFILLER_0_216_1261 VPWR VGND VPWR VGND sky130_ef_sc_hd__decap_12
XFILLER_0_72_1225 VGND VGND VPWR VPWR sky130_fd_sc_hd__fill_1
XFILLER_0_212_1147 VGND VGND VPWR VPWR sky130_fd_sc_hd__fill_1
XFILLER_0_70_10 VPWR VGND VPWR VGND sky130_ef_sc_hd__decap_12
XFILLER_0_58_631 VPWR VGND VPWR VGND sky130_ef_sc_hd__decap_12
XFILLER_0_175_647 VGND VGND VPWR VPWR sky130_fd_sc_hd__decap_8
XFILLER_0_161_34 VPWR VGND VPWR VGND sky130_ef_sc_hd__decap_12
XFILLER_0_190_617 VGND VGND VPWR VPWR sky130_fd_sc_hd__fill_1
XFILLER_0_73_645 VGND VGND VPWR VPWR sky130_fd_sc_hd__fill_1
XFILLER_0_147_1311 VPWR VGND VPWR VGND sky130_ef_sc_hd__decap_12
XFILLER_0_6_923 VGND VGND VPWR VPWR sky130_fd_sc_hd__fill_1
XFILLER_0_182_1213 VPWR VGND VPWR VGND sky130_ef_sc_hd__decap_12
XFILLER_0_104_909 VPWR VGND VPWR VGND sky130_ef_sc_hd__decap_12
XANTENNA_u_pe11_weight_in[12] net152 VGND VGND VPWR VPWR sky130_fd_sc_hd__diode_2
XFILLER_0_108_1317 VPWR VGND VPWR VGND sky130_ef_sc_hd__decap_12
XANTENNA_u_pe01_psum_in[26] net84 VGND VGND VPWR VPWR sky130_fd_sc_hd__diode_2
XFILLER_0_111_441 VGND VGND VPWR VPWR sky130_fd_sc_hd__decap_6
XFILLER_0_223_1287 VGND VGND VPWR VPWR sky130_fd_sc_hd__fill_1
XFILLER_0_106_1085 VGND VGND VPWR VPWR sky130_fd_sc_hd__decap_6
XFILLER_0_111_485 VPWR VGND VPWR VGND sky130_ef_sc_hd__decap_12
XFILLER_0_226_832 VGND VGND VPWR VPWR sky130_fd_sc_hd__decap_8
XFILLER_0_226_810 VGND VGND VPWR VPWR sky130_fd_sc_hd__fill_2
XFILLER_0_0_193 VGND VGND VPWR VPWR sky130_fd_sc_hd__decap_3
XFILLER_0_213_559 VGND VGND VPWR VPWR sky130_fd_sc_hd__fill_1
XTAP_2317 VGND VPWR sky130_fd_sc_hd__tapvpwrvgnd_1
XFILLER_0_154_1337 VGND VGND VPWR VPWR sky130_fd_sc_hd__fill_1
XTAP_2306 VGND VPWR sky130_fd_sc_hd__tapvpwrvgnd_1
XFILLER_0_205_27 VPWR VGND VPWR VGND sky130_ef_sc_hd__decap_12
XTAP_2339 VGND VPWR sky130_fd_sc_hd__tapvpwrvgnd_1
XTAP_2328 VGND VPWR sky130_fd_sc_hd__tapvpwrvgnd_1
XTAP_1605 VGND VPWR sky130_fd_sc_hd__tapvpwrvgnd_1
XFILLER_0_113_1001 VGND VGND VPWR VPWR sky130_fd_sc_hd__decap_6
XTAP_1638 VGND VPWR sky130_fd_sc_hd__tapvpwrvgnd_1
XTAP_1616 VGND VPWR sky130_fd_sc_hd__tapvpwrvgnd_1
XTAP_1627 VGND VPWR sky130_fd_sc_hd__tapvpwrvgnd_1
XFILLER_0_51_1309 VGND VGND VPWR VPWR sky130_fd_sc_hd__fill_1
XTAP_1649 VGND VPWR sky130_fd_sc_hd__tapvpwrvgnd_1
XFILLER_0_113_1045 VPWR VGND VPWR VGND sky130_ef_sc_hd__decap_12
XFILLER_0_181_617 VPWR VGND VPWR VGND sky130_ef_sc_hd__decap_12
XFILLER_0_221_15 VPWR VGND VPWR VGND sky130_ef_sc_hd__decap_12
XFILLER_0_113_1089 VPWR VGND VPWR VGND sky130_ef_sc_hd__decap_12
XFILLER_0_49_1249 VGND VGND VPWR VPWR sky130_fd_sc_hd__decap_4
XFILLER_0_224_1029 VGND VGND VPWR VPWR sky130_fd_sc_hd__decap_6
XFILLER_0_198_1275 VGND VGND VPWR VPWR sky130_fd_sc_hd__decap_6
XFILLER_0_217_821 VPWR VGND VPWR VGND sky130_ef_sc_hd__decap_12
XFILLER_0_217_865 VPWR VGND VPWR VGND sky130_ef_sc_hd__decap_12
XFILLER_0_159_1237 VPWR VGND VPWR VGND sky130_ef_sc_hd__decap_12
XFILLER_0_95_1225 VPWR VGND VPWR VGND sky130_ef_sc_hd__decap_12
XTAP_2862 VGND VPWR sky130_fd_sc_hd__tapvpwrvgnd_1
XTAP_2840 VGND VPWR sky130_fd_sc_hd__tapvpwrvgnd_1
XFILLER_0_212_581 VGND VGND VPWR VPWR sky130_fd_sc_hd__decap_6
XTAP_2873 VGND VPWR sky130_fd_sc_hd__tapvpwrvgnd_1
XTAP_2851 VGND VPWR sky130_fd_sc_hd__tapvpwrvgnd_1
XFILLER_0_24_25 VGND VGND VPWR VPWR sky130_fd_sc_hd__decap_3
XFILLER_0_115_49 VGND VGND VPWR VPWR sky130_fd_sc_hd__fill_1
XTAP_2895 VGND VPWR sky130_fd_sc_hd__tapvpwrvgnd_1
XTAP_2884 VGND VPWR sky130_fd_sc_hd__tapvpwrvgnd_1
XFILLER_0_157_647 VGND VGND VPWR VPWR sky130_fd_sc_hd__decap_8
XFILLER_0_172_617 VGND VGND VPWR VPWR sky130_fd_sc_hd__fill_1
XFILLER_0_55_645 VGND VGND VPWR VPWR sky130_fd_sc_hd__fill_1
XFILLER_0_71_1291 VPWR VGND VPWR VGND sky130_ef_sc_hd__decap_12
XFILLER_0_131_15 VPWR VGND VPWR VGND sky130_ef_sc_hd__decap_12
XFILLER_0_32_1275 VGND VGND VPWR VPWR sky130_fd_sc_hd__decap_6
XFILLER_0_211_81 VPWR VGND VPWR VGND sky130_ef_sc_hd__decap_12
XFILLER_0_207_1249 VGND VGND VPWR VPWR sky130_fd_sc_hd__decap_4
Xoutput206 net206 VGND VGND VPWR VPWR psum_col1_out[18] sky130_fd_sc_hd__clkbuf_4
Xoutput217 net217 VGND VGND VPWR VPWR psum_col1_out[28] sky130_fd_sc_hd__clkbuf_4
Xoutput228 net228 VGND VGND VPWR VPWR psum_col1_out[9] sky130_fd_sc_hd__clkbuf_4
XFILLER_0_2_469 VGND VGND VPWR VPWR sky130_fd_sc_hd__decap_6
XFILLER_0_142_1263 VPWR VGND VPWR VGND sky130_ef_sc_hd__decap_12
XFILLER_0_103_1225 VPWR VGND VPWR VGND sky130_ef_sc_hd__decap_12
XFILLER_0_226_106 VGND VGND VPWR VPWR sky130_fd_sc_hd__decap_6
XFILLER_0_222_301 VGND VGND VPWR VPWR sky130_fd_sc_hd__decap_6
XFILLER_0_222_345 VPWR VGND VPWR VGND sky130_ef_sc_hd__decap_12
XFILLER_0_216_1091 VGND VGND VPWR VPWR sky130_fd_sc_hd__fill_1
XFILLER_0_222_389 VPWR VGND VPWR VGND sky130_ef_sc_hd__decap_12
XFILLER_0_110_1229 VPWR VGND VPWR VGND sky130_ef_sc_hd__decap_12
XFILLER_0_163_617 VPWR VGND VPWR VGND sky130_ef_sc_hd__decap_12
XFILLER_0_50_1331 VGND VGND VPWR VPWR sky130_fd_sc_hd__decap_6
XFILLER_0_105_93 VPWR VGND VPWR VGND sky130_ef_sc_hd__decap_12
XFILLER_0_184_1319 VPWR VGND VPWR VGND sky130_ef_sc_hd__decap_12
XFILLER_0_2_1173 VPWR VGND VPWR VGND sky130_ef_sc_hd__decap_12
XFILLER_0_90_3 VPWR VGND VPWR VGND sky130_ef_sc_hd__decap_12
XFILLER_0_108_1147 VGND VGND VPWR VPWR sky130_fd_sc_hd__fill_1
XFILLER_0_121_1303 VGND VGND VPWR VPWR sky130_fd_sc_hd__decap_6
XFILLER_0_2_981 VPWR VGND VPWR VGND sky130_ef_sc_hd__decap_12
XFILLER_0_111_293 VPWR VGND VPWR VGND sky130_ef_sc_hd__decap_12
XFILLER_0_226_673 VGND VGND VPWR VPWR sky130_fd_sc_hd__decap_8
XFILLER_0_214_813 VPWR VGND VPWR VGND sky130_ef_sc_hd__decap_12
XFILLER_0_225_161 VGND VGND VPWR VPWR sky130_fd_sc_hd__decap_6
XFILLER_0_216_15 VPWR VGND VPWR VGND sky130_ef_sc_hd__decap_12
XFILLER_0_158_1281 VGND VGND VPWR VPWR sky130_fd_sc_hd__fill_1
XTAP_2125 VGND VPWR sky130_fd_sc_hd__tapvpwrvgnd_1
XTAP_2114 VGND VPWR sky130_fd_sc_hd__tapvpwrvgnd_1
XTAP_2103 VGND VPWR sky130_fd_sc_hd__tapvpwrvgnd_1
XTAP_2147 VGND VPWR sky130_fd_sc_hd__tapvpwrvgnd_1
XTAP_2136 VGND VPWR sky130_fd_sc_hd__tapvpwrvgnd_1
XTAP_2158 VGND VPWR sky130_fd_sc_hd__tapvpwrvgnd_1
XTAP_1413 VGND VPWR sky130_fd_sc_hd__tapvpwrvgnd_1
XTAP_1424 VGND VPWR sky130_fd_sc_hd__tapvpwrvgnd_1
XTAP_1402 VGND VPWR sky130_fd_sc_hd__tapvpwrvgnd_1
XFILLER_0_55_1253 VGND VGND VPWR VPWR sky130_fd_sc_hd__fill_1
XFILLER_0_139_647 VGND VGND VPWR VPWR sky130_fd_sc_hd__decap_8
XTAP_1435 VGND VPWR sky130_fd_sc_hd__tapvpwrvgnd_1
XTAP_1446 VGND VPWR sky130_fd_sc_hd__tapvpwrvgnd_1
XTAP_1457 VGND VPWR sky130_fd_sc_hd__tapvpwrvgnd_1
XTAP_2169 VGND VPWR sky130_fd_sc_hd__tapvpwrvgnd_1
XANTENNA_input109_A w00[2] VGND VGND VPWR VPWR sky130_fd_sc_hd__diode_2
XFILLER_0_154_617 VGND VGND VPWR VPWR sky130_fd_sc_hd__fill_1
XTAP_1468 VGND VPWR sky130_fd_sc_hd__tapvpwrvgnd_1
XTAP_1479 VGND VPWR sky130_fd_sc_hd__tapvpwrvgnd_1
XFILLER_0_37_645 VGND VGND VPWR VPWR sky130_fd_sc_hd__fill_1
XANTENNA_input74_A psum_col1_in[17] VGND VGND VPWR VPWR sky130_fd_sc_hd__diode_2
XFILLER_0_126_1225 VGND VGND VPWR VPWR sky130_fd_sc_hd__fill_1
XFILLER_0_10_49 VGND VGND VPWR VPWR sky130_fd_sc_hd__fill_1
XFILLER_0_27_1311 VPWR VGND VPWR VGND sky130_ef_sc_hd__decap_12
XFILLER_0_62_1213 VPWR VGND VPWR VGND sky130_ef_sc_hd__decap_12
XFILLER_0_209_629 VPWR VGND VPWR VGND sky130_ef_sc_hd__decap_12
XFILLER_0_97_1309 VGND VGND VPWR VPWR sky130_fd_sc_hd__fill_1
XFILLER_0_19_47 VGND VGND VPWR VPWR sky130_fd_sc_hd__decap_3
XFILLER_0_217_673 VPWR VGND VPWR VGND sky130_ef_sc_hd__decap_12
XANTENNA_output230_A net230 VGND VGND VPWR VPWR sky130_fd_sc_hd__diode_2
XFILLER_0_172_1201 VPWR VGND VPWR VGND sky130_ef_sc_hd__decap_12
XFILLER_0_35_13 VPWR VGND VPWR VGND sky130_ef_sc_hd__decap_12
XFILLER_0_220_805 VGND VGND VPWR VPWR sky130_fd_sc_hd__decap_6
XFILLER_0_220_849 VPWR VGND VPWR VGND sky130_ef_sc_hd__decap_12
XFILLER_0_150_6 VGND VGND VPWR VPWR sky130_fd_sc_hd__fill_2
XTAP_2681 VGND VPWR sky130_fd_sc_hd__tapvpwrvgnd_1
XFILLER_0_213_1231 VGND VGND VPWR VPWR sky130_fd_sc_hd__fill_1
XTAP_2670 VGND VPWR sky130_fd_sc_hd__tapvpwrvgnd_1
XFILLER_0_34_1337 VGND VGND VPWR VPWR sky130_fd_sc_hd__fill_1
XTAP_2692 VGND VPWR sky130_fd_sc_hd__tapvpwrvgnd_1
XFILLER_0_145_617 VPWR VGND VPWR VGND sky130_ef_sc_hd__decap_12
XTAP_1991 VGND VPWR sky130_fd_sc_hd__tapvpwrvgnd_1
XFILLER_0_7_517 VPWR VGND VPWR VGND sky130_ef_sc_hd__decap_12
XTAP_1980 VGND VPWR sky130_fd_sc_hd__tapvpwrvgnd_1
XFILLER_0_113_503 VGND VGND VPWR VPWR sky130_fd_sc_hd__fill_1
XFILLER_0_2_233 VPWR VGND VPWR VGND sky130_ef_sc_hd__decap_12
XFILLER_0_2_277 VPWR VGND VPWR VGND sky130_ef_sc_hd__decap_12
XFILLER_0_214_109 VPWR VGND VPWR VGND sky130_ef_sc_hd__decap_12
XFILLER_0_39_1237 VPWR VGND VPWR VGND sky130_ef_sc_hd__decap_12
XFILLER_0_78_1275 VGND VGND VPWR VPWR sky130_fd_sc_hd__decap_6
XFILLER_0_223_665 VGND VGND VPWR VPWR sky130_fd_sc_hd__decap_6
XFILLER_0_222_153 VPWR VGND VPWR VGND sky130_ef_sc_hd__decap_12
XFILLER_0_92_41 VGND VGND VPWR VPWR sky130_fd_sc_hd__decap_8
XFILLER_0_218_1197 VGND VGND VPWR VPWR sky130_fd_sc_hd__decap_6
XFILLER_0_214_1017 VPWR VGND VPWR VGND sky130_ef_sc_hd__decap_12
XFILLER_0_222_197 VPWR VGND VPWR VGND sky130_ef_sc_hd__decap_12
XFILLER_0_210_337 VPWR VGND VPWR VGND sky130_ef_sc_hd__decap_12
XPHY_507 VGND VGND VPWR VPWR sky130_fd_sc_hd__decap_3
XFILLER_0_114_1173 VGND VGND VPWR VPWR sky130_fd_sc_hd__decap_3
XPHY_518 VGND VGND VPWR VPWR sky130_fd_sc_hd__decap_3
XFILLER_0_109_809 VPWR VGND VPWR VGND sky130_ef_sc_hd__decap_12
XPHY_529 VGND VGND VPWR VPWR sky130_fd_sc_hd__decap_3
XPHY_1128 VGND VGND VPWR VPWR sky130_fd_sc_hd__decap_3
XPHY_1117 VGND VGND VPWR VPWR sky130_fd_sc_hd__decap_3
XFILLER_0_188_1263 VPWR VGND VPWR VGND sky130_ef_sc_hd__decap_12
XPHY_1139 VGND VGND VPWR VPWR sky130_fd_sc_hd__decap_3
XPHY_1106 VGND VGND VPWR VPWR sky130_fd_sc_hd__decap_3
XFILLER_0_110_1037 VPWR VGND VPWR VGND sky130_ef_sc_hd__decap_12
XFILLER_0_136_617 VGND VGND VPWR VPWR sky130_fd_sc_hd__fill_1
XFILLER_0_19_645 VGND VGND VPWR VPWR sky130_fd_sc_hd__fill_1
XFILLER_0_149_1225 VPWR VGND VPWR VGND sky130_ef_sc_hd__decap_12
XFILLER_0_85_1213 VPWR VGND VPWR VGND sky130_ef_sc_hd__decap_12
XFILLER_0_225_1113 VGND VGND VPWR VPWR sky130_fd_sc_hd__decap_6
XFILLER_0_85_1279 VPWR VGND VPWR VGND sky130_ef_sc_hd__decap_12
XFILLER_0_225_1157 VPWR VGND VPWR VGND sky130_ef_sc_hd__decap_12
XFILLER_0_125_1291 VPWR VGND VPWR VGND sky130_ef_sc_hd__decap_12
XFILLER_0_195_1201 VPWR VGND VPWR VGND sky130_ef_sc_hd__decap_12
XFILLER_0_96_1331 VGND VGND VPWR VPWR sky130_fd_sc_hd__decap_6
XFILLER_0_22_1263 VPWR VGND VPWR VGND sky130_ef_sc_hd__decap_12
XFILLER_0_195_1267 VPWR VGND VPWR VGND sky130_ef_sc_hd__decap_12
XFILLER_0_214_643 VGND VGND VPWR VPWR sky130_fd_sc_hd__fill_1
XFILLER_0_92_1239 VPWR VGND VPWR VGND sky130_ef_sc_hd__decap_12
XTAP_1221 VGND VPWR sky130_fd_sc_hd__tapvpwrvgnd_1
XTAP_1232 VGND VPWR sky130_fd_sc_hd__tapvpwrvgnd_1
XFILLER_0_132_1251 VPWR VGND VPWR VGND sky130_ef_sc_hd__decap_12
XTAP_1243 VGND VPWR sky130_fd_sc_hd__tapvpwrvgnd_1
XTAP_1265 VGND VPWR sky130_fd_sc_hd__tapvpwrvgnd_1
XTAP_1254 VGND VPWR sky130_fd_sc_hd__tapvpwrvgnd_1
XFILLER_0_167_1303 VGND VGND VPWR VPWR sky130_fd_sc_hd__decap_6
XFILLER_0_132_1295 VPWR VGND VPWR VGND sky130_ef_sc_hd__decap_12
XFILLER_0_127_617 VPWR VGND VPWR VGND sky130_ef_sc_hd__decap_12
XTAP_1298 VGND VPWR sky130_fd_sc_hd__tapvpwrvgnd_1
XTAP_1276 VGND VPWR sky130_fd_sc_hd__tapvpwrvgnd_1
XTAP_1287 VGND VPWR sky130_fd_sc_hd__tapvpwrvgnd_1
XFILLER_0_21_37 VGND VGND VPWR VPWR sky130_fd_sc_hd__decap_8
XFILLER_0_150_631 VPWR VGND VPWR VGND sky130_ef_sc_hd__decap_12
XFILLER_0_64_1319 VPWR VGND VPWR VGND sky130_ef_sc_hd__decap_12
XFILLER_0_107_385 VGND VGND VPWR VPWR sky130_fd_sc_hd__decap_6
XANTENNA_u_pe10_weight_in[2] net141 VGND VGND VPWR VPWR sky130_fd_sc_hd__diode_2
XFILLER_0_174_1307 VPWR VGND VPWR VGND sky130_ef_sc_hd__decap_12
XFILLER_0_100_1239 VPWR VGND VPWR VGND sky130_ef_sc_hd__decap_12
XFILLER_0_137_47 VGND VGND VPWR VPWR sky130_fd_sc_hd__decap_3
XFILLER_0_218_993 VPWR VGND VPWR VGND sky130_ef_sc_hd__decap_12
XFILLER_0_220_613 VPWR VGND VPWR VGND sky130_ef_sc_hd__decap_12
XFILLER_0_1_25 VPWR VGND VPWR VGND sky130_ef_sc_hd__decap_12
XFILLER_0_220_657 VPWR VGND VPWR VGND sky130_ef_sc_hd__decap_12
XFILLER_0_1_69 VPWR VGND VPWR VGND sky130_ef_sc_hd__decap_12
XFILLER_0_38_1281 VGND VGND VPWR VPWR sky130_fd_sc_hd__fill_1
XFILLER_0_111_1313 VPWR VGND VPWR VGND sky130_ef_sc_hd__decap_12
XFILLER_0_118_617 VGND VGND VPWR VPWR sky130_fd_sc_hd__fill_1
XFILLER_0_109_1231 VGND VGND VPWR VPWR sky130_fd_sc_hd__fill_1
XFILLER_0_3_553 VGND VGND VPWR VPWR sky130_fd_sc_hd__decap_6
XFILLER_0_31_629 VPWR VGND VPWR VGND sky130_ef_sc_hd__decap_12
XFILLER_0_3_597 VPWR VGND VPWR VGND sky130_ef_sc_hd__decap_12
XFILLER_0_53_3 VPWR VGND VPWR VGND sky130_ef_sc_hd__decap_12
XFILLER_0_215_429 VPWR VGND VPWR VGND sky130_ef_sc_hd__decap_12
XFILLER_0_223_473 VPWR VGND VPWR VGND sky130_ef_sc_hd__decap_12
XFILLER_0_116_1213 VPWR VGND VPWR VGND sky130_ef_sc_hd__decap_12
XFILLER_0_52_1201 VPWR VGND VPWR VGND sky130_ef_sc_hd__decap_12
XFILLER_0_210_167 VGND VGND VPWR VPWR sky130_fd_sc_hd__fill_1
XPHY_304 VGND VGND VPWR VPWR sky130_fd_sc_hd__decap_3
XPHY_315 VGND VGND VPWR VPWR sky130_fd_sc_hd__decap_3
XFILLER_0_213_49 VGND VGND VPWR VPWR sky130_fd_sc_hd__decap_6
XFILLER_0_109_617 VPWR VGND VPWR VGND sky130_ef_sc_hd__decap_12
XPHY_359 VGND VGND VPWR VPWR sky130_fd_sc_hd__decap_3
XPHY_337 VGND VGND VPWR VPWR sky130_fd_sc_hd__decap_3
XPHY_348 VGND VGND VPWR VPWR sky130_fd_sc_hd__decap_3
XPHY_326 VGND VGND VPWR VPWR sky130_fd_sc_hd__decap_3
XFILLER_0_132_631 VPWR VGND VPWR VGND sky130_ef_sc_hd__decap_12
XFILLER_0_7_881 VPWR VGND VPWR VGND sky130_ef_sc_hd__decap_12
XFILLER_0_104_333 VGND VGND VPWR VPWR sky130_fd_sc_hd__decap_3
XFILLER_0_105_889 VGND VGND VPWR VPWR sky130_fd_sc_hd__decap_6
XFILLER_0_218_245 VGND VGND VPWR VPWR sky130_fd_sc_hd__decap_6
XANTENNA_input37_A psum_col0_in[12] VGND VGND VPWR VPWR sky130_fd_sc_hd__diode_2
XFILLER_0_218_289 VPWR VGND VPWR VGND sky130_ef_sc_hd__decap_12
XFILLER_0_89_629 VPWR VGND VPWR VGND sky130_ef_sc_hd__decap_12
XFILLER_0_16_15 VPWR VGND VPWR VGND sky130_ef_sc_hd__decap_12
XFILLER_0_107_39 VPWR VGND VPWR VGND sky130_ef_sc_hd__decap_12
XFILLER_0_210_1201 VGND VGND VPWR VPWR sky130_fd_sc_hd__decap_3
XFILLER_0_210_1245 VPWR VGND VPWR VGND sky130_ef_sc_hd__decap_12
XFILLER_0_123_27 VPWR VGND VPWR VGND sky130_ef_sc_hd__decap_12
XPHY_871 VGND VGND VPWR VPWR sky130_fd_sc_hd__decap_3
XPHY_860 VGND VGND VPWR VPWR sky130_fd_sc_hd__decap_3
XFILLER_0_210_1289 VPWR VGND VPWR VGND sky130_ef_sc_hd__decap_12
XPHY_882 VGND VGND VPWR VPWR sky130_fd_sc_hd__decap_3
XPHY_893 VGND VGND VPWR VPWR sky130_fd_sc_hd__decap_3
XFILLER_0_68_1263 VPWR VGND VPWR VGND sky130_ef_sc_hd__decap_12
XFILLER_0_13_629 VPWR VGND VPWR VGND sky130_ef_sc_hd__decap_12
XFILLER_0_29_1225 VPWR VGND VPWR VGND sky130_ef_sc_hd__decap_12
XFILLER_0_107_193 VPWR VGND VPWR VGND sky130_ef_sc_hd__decap_12
XFILLER_0_0_501 VGND VGND VPWR VPWR sky130_fd_sc_hd__decap_3
XFILLER_0_0_589 VGND VGND VPWR VPWR sky130_fd_sc_hd__decap_8
XFILLER_0_225_727 VGND VGND VPWR VPWR sky130_fd_sc_hd__fill_1
XFILLER_0_104_1161 VPWR VGND VPWR VGND sky130_ef_sc_hd__decap_12
XFILLER_0_178_1251 VPWR VGND VPWR VGND sky130_ef_sc_hd__decap_12
XFILLER_0_139_1213 VPWR VGND VPWR VGND sky130_ef_sc_hd__decap_12
XFILLER_0_178_1295 VPWR VGND VPWR VGND sky130_ef_sc_hd__decap_12
XFILLER_0_73_10 VPWR VGND VPWR VGND sky130_ef_sc_hd__decap_12
XFILLER_0_75_1201 VPWR VGND VPWR VGND sky130_ef_sc_hd__decap_12
XFILLER_0_219_1281 VGND VGND VPWR VPWR sky130_fd_sc_hd__decap_6
XFILLER_0_215_1101 VPWR VGND VPWR VGND sky130_ef_sc_hd__decap_12
XFILLER_0_221_933 VPWR VGND VPWR VGND sky130_ef_sc_hd__decap_12
XFILLER_0_139_1279 VPWR VGND VPWR VGND sky130_ef_sc_hd__decap_12
XFILLER_0_75_1267 VPWR VGND VPWR VGND sky130_ef_sc_hd__decap_12
XFILLER_0_215_1145 VPWR VGND VPWR VGND sky130_ef_sc_hd__decap_12
XFILLER_0_220_421 VPWR VGND VPWR VGND sky130_ef_sc_hd__decap_12
XFILLER_0_215_1189 VPWR VGND VPWR VGND sky130_ef_sc_hd__decap_12
XFILLER_0_211_1009 VPWR VGND VPWR VGND sky130_ef_sc_hd__decap_12
XFILLER_0_221_977 VPWR VGND VPWR VGND sky130_ef_sc_hd__decap_12
XFILLER_0_111_1121 VPWR VGND VPWR VGND sky130_ef_sc_hd__decap_12
XFILLER_0_12_1251 VPWR VGND VPWR VGND sky130_ef_sc_hd__decap_12
XANTENNA_u_pe00_clk clknet_1_1__leaf_clk VGND VGND VPWR VPWR sky130_fd_sc_hd__diode_2
XFILLER_0_185_1255 VPWR VGND VPWR VGND sky130_ef_sc_hd__decap_12
XFILLER_0_12_1295 VPWR VGND VPWR VGND sky130_ef_sc_hd__decap_12
XFILLER_0_47_1303 VGND VGND VPWR VPWR sky130_fd_sc_hd__decap_6
XFILLER_0_113_93 VPWR VGND VPWR VGND sky130_ef_sc_hd__decap_12
XFILLER_0_146_1239 VPWR VGND VPWR VGND sky130_ef_sc_hd__decap_12
XFILLER_0_82_1227 VPWR VGND VPWR VGND sky130_ef_sc_hd__decap_12
XFILLER_0_222_1105 VPWR VGND VPWR VGND sky130_ef_sc_hd__decap_12
XFILLER_0_114_697 VGND VGND VPWR VPWR sky130_fd_sc_hd__decap_3
XFILLER_0_3_361 VPWR VGND VPWR VGND sky130_ef_sc_hd__decap_12
XFILLER_0_222_1149 VPWR VGND VPWR VGND sky130_ef_sc_hd__decap_12
XFILLER_0_122_1283 VPWR VGND VPWR VGND sky130_ef_sc_hd__decap_12
XFILLER_0_110_881 VPWR VGND VPWR VGND sky130_ef_sc_hd__decap_12
Xinput117 w01[0] VGND VGND VPWR VPWR net117 sky130_fd_sc_hd__buf_4
Xinput106 w00[14] VGND VGND VPWR VPWR net106 sky130_fd_sc_hd__buf_1
XFILLER_0_216_749 VGND VGND VPWR VPWR sky130_fd_sc_hd__decap_6
Xinput139 w10[15] VGND VGND VPWR VPWR net139 sky130_fd_sc_hd__clkbuf_4
XFILLER_0_208_49 VGND VGND VPWR VPWR sky130_fd_sc_hd__fill_1
XFILLER_0_208_27 VGND VGND VPWR VPWR sky130_fd_sc_hd__fill_1
Xinput128 w01[5] VGND VGND VPWR VPWR net128 sky130_fd_sc_hd__buf_4
XFILLER_0_215_237 VPWR VGND VPWR VGND sky130_ef_sc_hd__decap_12
XFILLER_0_157_1335 VGND VGND VPWR VPWR sky130_fd_sc_hd__decap_8
XFILLER_0_93_1323 VPWR VGND VPWR VGND sky130_ef_sc_hd__decap_12
XFILLER_0_224_793 VPWR VGND VPWR VGND sky130_ef_sc_hd__decap_12
XANTENNA_u_pe00_act_in[10] net2 VGND VGND VPWR VPWR sky130_fd_sc_hd__diode_2
XFILLER_0_118_1319 VPWR VGND VPWR VGND sky130_ef_sc_hd__decap_12
XFILLER_0_54_1307 VPWR VGND VPWR VGND sky130_ef_sc_hd__decap_12
XFILLER_0_223_281 VPWR VGND VPWR VGND sky130_ef_sc_hd__decap_12
XFILLER_0_6_1105 VPWR VGND VPWR VGND sky130_ef_sc_hd__decap_12
XFILLER_0_94_643 VPWR VGND VPWR VGND sky130_ef_sc_hd__decap_12
XPHY_112 VGND VGND VPWR VPWR sky130_fd_sc_hd__decap_3
XPHY_101 VGND VGND VPWR VPWR sky130_fd_sc_hd__decap_3
XFILLER_0_6_1149 VPWR VGND VPWR VGND sky130_ef_sc_hd__decap_12
XPHY_123 VGND VGND VPWR VPWR sky130_fd_sc_hd__decap_3
XPHY_134 VGND VGND VPWR VPWR sky130_fd_sc_hd__decap_3
XPHY_167 VGND VGND VPWR VPWR sky130_fd_sc_hd__decap_3
XPHY_145 VGND VGND VPWR VPWR sky130_fd_sc_hd__decap_3
XPHY_156 VGND VGND VPWR VPWR sky130_fd_sc_hd__decap_3
XFILLER_0_109_447 VGND VGND VPWR VPWR sky130_fd_sc_hd__fill_1
XPHY_178 VGND VGND VPWR VPWR sky130_fd_sc_hd__decap_3
XPHY_189 VGND VGND VPWR VPWR sky130_fd_sc_hd__decap_3
XFILLER_0_164_1339 VGND VGND VPWR VPWR sky130_fd_sc_hd__decap_4
XFILLER_0_105_653 VPWR VGND VPWR VGND sky130_ef_sc_hd__decap_12
XFILLER_0_205_1303 VGND VGND VPWR VPWR sky130_fd_sc_hd__decap_6
XFILLER_0_105_697 VPWR VGND VPWR VGND sky130_ef_sc_hd__decap_12
XFILLER_0_104_141 VPWR VGND VPWR VGND sky130_ef_sc_hd__decap_12
XFILLER_0_98_1201 VPWR VGND VPWR VGND sky130_ef_sc_hd__decap_12
XFILLER_0_101_1323 VPWR VGND VPWR VGND sky130_ef_sc_hd__decap_12
XFILLER_0_182_9 VGND VGND VPWR VPWR sky130_fd_sc_hd__fill_2
XFILLER_0_118_27 VGND VGND VPWR VPWR sky130_fd_sc_hd__fill_1
XFILLER_0_118_49 VGND VGND VPWR VPWR sky130_fd_sc_hd__fill_1
XFILLER_0_27_47 VGND VGND VPWR VPWR sky130_fd_sc_hd__fill_1
XFILLER_0_134_15 VPWR VGND VPWR VGND sky130_ef_sc_hd__decap_12
XFILLER_0_212_1329 VPWR VGND VPWR VGND sky130_ef_sc_hd__decap_12
XFILLER_0_187_645 VGND VGND VPWR VPWR sky130_fd_sc_hd__fill_1
XPHY_3 VGND VGND VPWR VPWR sky130_fd_sc_hd__decap_3
XFILLER_0_210_1075 VPWR VGND VPWR VGND sky130_ef_sc_hd__decap_12
XANTENNA_u_pe11_weight_in[9] net164 VGND VGND VPWR VPWR sky130_fd_sc_hd__diode_2
XPHY_690 VGND VGND VPWR VPWR sky130_fd_sc_hd__decap_3
XFILLER_0_5_615 VGND VGND VPWR VPWR sky130_fd_sc_hd__fill_1
XFILLER_0_111_3 VPWR VGND VPWR VGND sky130_ef_sc_hd__decap_12
XANTENNA_u_pe00_psum_in[26] net52 VGND VGND VPWR VPWR sky130_fd_sc_hd__diode_2
XFILLER_0_209_3 VPWR VGND VPWR VGND sky130_ef_sc_hd__decap_12
XFILLER_0_7_13 VPWR VGND VPWR VGND sky130_ef_sc_hd__decap_12
XFILLER_0_1_821 VPWR VGND VPWR VGND sky130_ef_sc_hd__decap_12
XFILLER_0_7_57 VPWR VGND VPWR VGND sky130_ef_sc_hd__decap_12
XFILLER_0_1_865 VPWR VGND VPWR VGND sky130_ef_sc_hd__decap_12
XFILLER_0_110_133 VGND VGND VPWR VPWR sky130_fd_sc_hd__decap_6
XFILLER_0_110_177 VPWR VGND VPWR VGND sky130_ef_sc_hd__decap_12
XFILLER_0_221_741 VPWR VGND VPWR VGND sky130_ef_sc_hd__decap_12
XFILLER_0_16_3 VPWR VGND VPWR VGND sky130_ef_sc_hd__decap_12
XFILLER_0_220_251 VGND VGND VPWR VPWR sky130_fd_sc_hd__fill_1
XTAP_1809 VGND VPWR sky130_fd_sc_hd__tapvpwrvgnd_1
XFILLER_0_221_785 VPWR VGND VPWR VGND sky130_ef_sc_hd__decap_12
XFILLER_0_76_643 VPWR VGND VPWR VGND sky130_ef_sc_hd__decap_12
XFILLER_0_1_1057 VGND VGND VPWR VPWR sky130_fd_sc_hd__decap_6
XFILLER_0_107_1009 VPWR VGND VPWR VGND sky130_ef_sc_hd__decap_12
XFILLER_0_114_461 VPWR VGND VPWR VGND sky130_ef_sc_hd__decap_12
XFILLER_0_226_1093 VGND VGND VPWR VPWR sky130_fd_sc_hd__decap_8
XFILLER_0_4_681 VPWR VGND VPWR VGND sky130_ef_sc_hd__decap_12
XFILLER_0_219_15 VPWR VGND VPWR VGND sky130_ef_sc_hd__decap_12
XFILLER_0_216_513 VPWR VGND VPWR VGND sky130_ef_sc_hd__decap_12
XFILLER_0_216_557 VPWR VGND VPWR VGND sky130_ef_sc_hd__decap_12
XANTENNA_input139_A w10[15] VGND VGND VPWR VPWR sky130_fd_sc_hd__diode_2
XFILLER_0_58_1251 VPWR VGND VPWR VGND sky130_ef_sc_hd__decap_12
XFILLER_0_19_1213 VPWR VGND VPWR VGND sky130_ef_sc_hd__decap_12
XFILLER_0_170_1343 VGND VGND VPWR VPWR sky130_fd_sc_hd__fill_1
XFILLER_0_169_645 VGND VGND VPWR VPWR sky130_fd_sc_hd__fill_1
XFILLER_0_58_1295 VPWR VGND VPWR VGND sky130_ef_sc_hd__decap_12
XFILLER_0_211_273 VGND VGND VPWR VPWR sky130_fd_sc_hd__decap_6
XFILLER_0_19_1279 VPWR VGND VPWR VGND sky130_ef_sc_hd__decap_12
XFILLER_0_13_27 VPWR VGND VPWR VGND sky130_ef_sc_hd__decap_12
XFILLER_0_104_29 VPWR VGND VPWR VGND sky130_ef_sc_hd__decap_12
XFILLER_0_129_1201 VPWR VGND VPWR VGND sky130_ef_sc_hd__decap_12
XFILLER_0_168_1283 VPWR VGND VPWR VGND sky130_ef_sc_hd__decap_12
XFILLER_0_129_1267 VPWR VGND VPWR VGND sky130_ef_sc_hd__decap_12
XFILLER_0_106_973 VGND VGND VPWR VPWR sky130_fd_sc_hd__decap_6
XFILLER_0_105_461 VPWR VGND VPWR VGND sky130_ef_sc_hd__decap_12
XFILLER_0_209_1291 VPWR VGND VPWR VGND sky130_ef_sc_hd__decap_12
XFILLER_0_26_1239 VPWR VGND VPWR VGND sky130_ef_sc_hd__decap_12
XFILLER_0_65_1255 VPWR VGND VPWR VGND sky130_ef_sc_hd__decap_12
XFILLER_0_38_13 VPWR VGND VPWR VGND sky130_ef_sc_hd__decap_12
XFILLER_0_219_373 VPWR VGND VPWR VGND sky130_ef_sc_hd__decap_12
XFILLER_0_136_1227 VPWR VGND VPWR VGND sky130_ef_sc_hd__decap_12
XFILLER_0_145_47 VGND VGND VPWR VPWR sky130_fd_sc_hd__decap_3
XFILLER_0_216_1273 VPWR VGND VPWR VGND sky130_ef_sc_hd__decap_12
XFILLER_0_37_1335 VGND VGND VPWR VPWR sky130_fd_sc_hd__decap_8
XFILLER_0_159_3 VPWR VGND VPWR VGND sky130_ef_sc_hd__decap_12
XFILLER_0_58_643 VPWR VGND VPWR VGND sky130_ef_sc_hd__decap_12
XFILLER_0_70_22 VGND VGND VPWR VPWR sky130_fd_sc_hd__decap_6
XFILLER_0_161_46 VGND VGND VPWR VPWR sky130_fd_sc_hd__decap_4
XFILLER_0_182_1225 VGND VGND VPWR VPWR sky130_fd_sc_hd__fill_1
XFILLER_0_147_1323 VPWR VGND VPWR VGND sky130_ef_sc_hd__decap_12
XFILLER_0_6_979 VGND VGND VPWR VPWR sky130_fd_sc_hd__fill_1
XANTENNA_u_pe11_weight_in[11] net151 VGND VGND VPWR VPWR sky130_fd_sc_hd__diode_2
XFILLER_0_108_1329 VPWR VGND VPWR VGND sky130_ef_sc_hd__decap_12
XFILLER_0_83_1311 VPWR VGND VPWR VGND sky130_ef_sc_hd__decap_12
XFILLER_0_223_1233 VPWR VGND VPWR VGND sky130_ef_sc_hd__decap_12
XANTENNA_u_pe01_psum_in[25] net83 VGND VGND VPWR VPWR sky130_fd_sc_hd__diode_2
XFILLER_0_44_1339 VGND VGND VPWR VPWR sky130_fd_sc_hd__decap_4
XFILLER_0_110_83 VGND VGND VPWR VPWR sky130_fd_sc_hd__fill_1
XFILLER_0_111_497 VGND VGND VPWR VPWR sky130_fd_sc_hd__decap_6
XFILLER_0_1_673 VPWR VGND VPWR VGND sky130_ef_sc_hd__decap_12
XFILLER_0_226_844 VGND VGND VPWR VPWR sky130_fd_sc_hd__fill_2
XFILLER_0_193_1343 VGND VGND VPWR VPWR sky130_fd_sc_hd__fill_1
XFILLER_0_213_505 VPWR VGND VPWR VGND sky130_ef_sc_hd__decap_12
XTAP_2307 VGND VPWR sky130_fd_sc_hd__tapvpwrvgnd_1
XFILLER_0_90_1337 VGND VGND VPWR VPWR sky130_fd_sc_hd__fill_1
XTAP_2318 VGND VPWR sky130_fd_sc_hd__tapvpwrvgnd_1
XTAP_1606 VGND VPWR sky130_fd_sc_hd__tapvpwrvgnd_1
XTAP_2329 VGND VPWR sky130_fd_sc_hd__tapvpwrvgnd_1
XFILLER_0_205_39 VGND VGND VPWR VPWR sky130_fd_sc_hd__decap_8
XFILLER_0_7_1233 VPWR VGND VPWR VGND sky130_ef_sc_hd__decap_12
XTAP_1617 VGND VPWR sky130_fd_sc_hd__tapvpwrvgnd_1
XTAP_1628 VGND VPWR sky130_fd_sc_hd__tapvpwrvgnd_1
XTAP_1639 VGND VPWR sky130_fd_sc_hd__tapvpwrvgnd_1
XFILLER_0_113_1057 VGND VGND VPWR VPWR sky130_fd_sc_hd__decap_6
XFILLER_0_3_1119 VGND VGND VPWR VPWR sky130_fd_sc_hd__fill_1
XFILLER_0_181_629 VPWR VGND VPWR VGND sky130_ef_sc_hd__decap_12
XFILLER_0_221_27 VPWR VGND VPWR VGND sky130_ef_sc_hd__decap_12
XFILLER_0_161_1309 VGND VGND VPWR VPWR sky130_fd_sc_hd__fill_1
XFILLER_0_202_1339 VGND VGND VPWR VPWR sky130_fd_sc_hd__decap_3
XFILLER_0_5_3 VPWR VGND VPWR VGND sky130_ef_sc_hd__decap_12
XFILLER_0_217_833 VGND VGND VPWR VPWR sky130_fd_sc_hd__decap_6
XFILLER_0_216_321 VPWR VGND VPWR VGND sky130_ef_sc_hd__decap_12
XFILLER_0_159_1249 VGND VGND VPWR VPWR sky130_fd_sc_hd__decap_4
XFILLER_0_217_877 VPWR VGND VPWR VGND sky130_ef_sc_hd__decap_12
XFILLER_0_216_365 VPWR VGND VPWR VGND sky130_ef_sc_hd__decap_12
XFILLER_0_95_1237 VPWR VGND VPWR VGND sky130_ef_sc_hd__decap_12
XTAP_2830 VGND VPWR sky130_fd_sc_hd__tapvpwrvgnd_1
XTAP_2863 VGND VPWR sky130_fd_sc_hd__tapvpwrvgnd_1
XTAP_2841 VGND VPWR sky130_fd_sc_hd__tapvpwrvgnd_1
XTAP_2852 VGND VPWR sky130_fd_sc_hd__tapvpwrvgnd_1
XTAP_2896 VGND VPWR sky130_fd_sc_hd__tapvpwrvgnd_1
XTAP_2885 VGND VPWR sky130_fd_sc_hd__tapvpwrvgnd_1
XTAP_2874 VGND VPWR sky130_fd_sc_hd__tapvpwrvgnd_1
XFILLER_0_6_209 VPWR VGND VPWR VGND sky130_ef_sc_hd__decap_12
XFILLER_0_131_27 VPWR VGND VPWR VGND sky130_ef_sc_hd__decap_12
XFILLER_0_70_605 VPWR VGND VPWR VGND sky130_ef_sc_hd__decap_12
XFILLER_0_113_729 VPWR VGND VPWR VGND sky130_ef_sc_hd__decap_12
XFILLER_0_211_93 VPWR VGND VPWR VGND sky130_ef_sc_hd__decap_12
XFILLER_0_106_781 VPWR VGND VPWR VGND sky130_ef_sc_hd__decap_12
Xoutput207 net207 VGND VGND VPWR VPWR psum_col1_out[19] sky130_fd_sc_hd__clkbuf_4
XFILLER_0_181_1291 VPWR VGND VPWR VGND sky130_ef_sc_hd__decap_12
XFILLER_0_49_45 VGND VGND VPWR VPWR sky130_fd_sc_hd__decap_3
Xoutput218 net218 VGND VGND VPWR VPWR psum_col1_out[29] sky130_fd_sc_hd__clkbuf_4
Xoutput229 net229 VGND VGND VPWR VPWR valid_row0_out sky130_fd_sc_hd__clkbuf_4
XFILLER_0_142_1275 VGND VGND VPWR VPWR sky130_fd_sc_hd__decap_6
XFILLER_0_103_1237 VPWR VGND VPWR VGND sky130_ef_sc_hd__decap_12
XFILLER_0_219_181 VPWR VGND VPWR VGND sky130_ef_sc_hd__decap_12
XFILLER_0_222_357 VGND VGND VPWR VPWR sky130_fd_sc_hd__decap_6
XFILLER_0_203_593 VPWR VGND VPWR VGND sky130_ef_sc_hd__decap_12
XFILLER_0_50_1343 VGND VGND VPWR VPWR sky130_fd_sc_hd__fill_1
XFILLER_0_163_629 VPWR VGND VPWR VGND sky130_ef_sc_hd__decap_12
XFILLER_0_2_1141 VGND VGND VPWR VPWR sky130_fd_sc_hd__decap_6
XFILLER_0_61_605 VPWR VGND VPWR VGND sky130_ef_sc_hd__decap_12
XFILLER_0_104_729 VPWR VGND VPWR VGND sky130_ef_sc_hd__decap_12
XFILLER_0_83_3 VPWR VGND VPWR VGND sky130_ef_sc_hd__decap_12
XFILLER_0_2_1185 VPWR VGND VPWR VGND sky130_ef_sc_hd__decap_12
XFILLER_0_160_1331 VGND VGND VPWR VPWR sky130_fd_sc_hd__decap_6
XFILLER_0_48_1283 VPWR VGND VPWR VGND sky130_ef_sc_hd__decap_12
XFILLER_0_223_1063 VGND VGND VPWR VPWR sky130_fd_sc_hd__fill_1
XFILLER_0_2_993 VPWR VGND VPWR VGND sky130_ef_sc_hd__decap_12
XFILLER_0_111_261 VPWR VGND VPWR VGND sky130_ef_sc_hd__decap_12
XFILLER_0_214_825 VPWR VGND VPWR VGND sky130_ef_sc_hd__decap_12
XFILLER_0_216_27 VGND VGND VPWR VPWR sky130_fd_sc_hd__fill_1
XFILLER_0_213_335 VGND VGND VPWR VPWR sky130_fd_sc_hd__fill_1
XFILLER_0_214_869 VPWR VGND VPWR VGND sky130_ef_sc_hd__decap_12
XFILLER_0_119_1255 VPWR VGND VPWR VGND sky130_ef_sc_hd__decap_12
XFILLER_0_94_1281 VGND VGND VPWR VPWR sky130_fd_sc_hd__fill_1
XTAP_2126 VGND VPWR sky130_fd_sc_hd__tapvpwrvgnd_1
XTAP_2115 VGND VPWR sky130_fd_sc_hd__tapvpwrvgnd_1
XTAP_2104 VGND VPWR sky130_fd_sc_hd__tapvpwrvgnd_1
XTAP_2159 VGND VPWR sky130_fd_sc_hd__tapvpwrvgnd_1
XTAP_2148 VGND VPWR sky130_fd_sc_hd__tapvpwrvgnd_1
XTAP_2137 VGND VPWR sky130_fd_sc_hd__tapvpwrvgnd_1
XTAP_1414 VGND VPWR sky130_fd_sc_hd__tapvpwrvgnd_1
XTAP_1403 VGND VPWR sky130_fd_sc_hd__tapvpwrvgnd_1
XTAP_1425 VGND VPWR sky130_fd_sc_hd__tapvpwrvgnd_1
XTAP_1436 VGND VPWR sky130_fd_sc_hd__tapvpwrvgnd_1
XTAP_1447 VGND VPWR sky130_fd_sc_hd__tapvpwrvgnd_1
XFILLER_0_16_1227 VPWR VGND VPWR VGND sky130_ef_sc_hd__decap_12
XTAP_1469 VGND VPWR sky130_fd_sc_hd__tapvpwrvgnd_1
XTAP_1458 VGND VPWR sky130_fd_sc_hd__tapvpwrvgnd_1
XFILLER_0_52_605 VPWR VGND VPWR VGND sky130_ef_sc_hd__decap_12
XFILLER_0_165_1253 VGND VGND VPWR VPWR sky130_fd_sc_hd__fill_1
XANTENNA_input67_A psum_col1_in[10] VGND VGND VPWR VPWR sky130_fd_sc_hd__diode_2
XFILLER_0_27_1323 VPWR VGND VPWR VGND sky130_ef_sc_hd__decap_12
XFILLER_0_62_1225 VGND VGND VPWR VPWR sky130_fd_sc_hd__fill_1
XFILLER_0_206_1283 VPWR VGND VPWR VGND sky130_ef_sc_hd__decap_12
XFILLER_0_19_15 VPWR VGND VPWR VGND sky130_ef_sc_hd__decap_12
XFILLER_0_217_641 VPWR VGND VPWR VGND sky130_ef_sc_hd__decap_12
XFILLER_0_102_1281 VGND VGND VPWR VPWR sky130_fd_sc_hd__fill_1
XFILLER_0_217_685 VPWR VGND VPWR VGND sky130_ef_sc_hd__decap_12
XFILLER_0_172_1213 VPWR VGND VPWR VGND sky130_ef_sc_hd__decap_12
XFILLER_0_137_1311 VPWR VGND VPWR VGND sky130_ef_sc_hd__decap_12
XFILLER_0_35_25 VPWR VGND VPWR VGND sky130_ef_sc_hd__decap_12
XFILLER_0_216_195 VGND VGND VPWR VPWR sky130_fd_sc_hd__fill_1
XANTENNA_clkbuf_1_1__f_clk_A clknet_0_clk VGND VGND VPWR VPWR sky130_fd_sc_hd__diode_2
XFILLER_0_126_49 VGND VGND VPWR VPWR sky130_fd_sc_hd__fill_1
XFILLER_0_73_1343 VGND VGND VPWR VPWR sky130_fd_sc_hd__fill_1
XTAP_2660 VGND VPWR sky130_fd_sc_hd__tapvpwrvgnd_1
XTAP_2671 VGND VPWR sky130_fd_sc_hd__tapvpwrvgnd_1
XFILLER_0_142_15 VPWR VGND VPWR VGND sky130_ef_sc_hd__decap_12
XFILLER_0_143_6 VGND VGND VPWR VPWR sky130_fd_sc_hd__fill_2
XTAP_2682 VGND VPWR sky130_fd_sc_hd__tapvpwrvgnd_1
XFILLER_0_213_1287 VGND VGND VPWR VPWR sky130_fd_sc_hd__fill_1
XTAP_2693 VGND VPWR sky130_fd_sc_hd__tapvpwrvgnd_1
XTAP_1970 VGND VPWR sky130_fd_sc_hd__tapvpwrvgnd_1
XFILLER_0_145_629 VPWR VGND VPWR VGND sky130_ef_sc_hd__decap_12
XTAP_1992 VGND VPWR sky130_fd_sc_hd__tapvpwrvgnd_1
XFILLER_0_7_529 VGND VGND VPWR VPWR sky130_fd_sc_hd__decap_3
XTAP_1981 VGND VPWR sky130_fd_sc_hd__tapvpwrvgnd_1
XFILLER_0_43_605 VPWR VGND VPWR VGND sky130_ef_sc_hd__decap_12
XFILLER_0_144_1337 VGND VGND VPWR VPWR sky130_fd_sc_hd__fill_1
XFILLER_0_113_559 VGND VGND VPWR VPWR sky130_fd_sc_hd__fill_1
XFILLER_0_2_245 VGND VGND VPWR VPWR sky130_fd_sc_hd__decap_6
XFILLER_0_220_1203 VGND VGND VPWR VPWR sky130_fd_sc_hd__fill_1
XFILLER_0_2_289 VPWR VGND VPWR VGND sky130_ef_sc_hd__decap_12
XFILLER_0_41_1309 VGND VGND VPWR VPWR sky130_fd_sc_hd__fill_1
XFILLER_0_222_121 VPWR VGND VPWR VGND sky130_ef_sc_hd__decap_12
XFILLER_0_39_1249 VGND VGND VPWR VPWR sky130_fd_sc_hd__decap_4
XFILLER_0_214_1029 VGND VGND VPWR VPWR sky130_fd_sc_hd__decap_6
XFILLER_0_211_839 VGND VGND VPWR VPWR sky130_fd_sc_hd__fill_1
XFILLER_0_222_165 VPWR VGND VPWR VGND sky130_ef_sc_hd__decap_12
XFILLER_0_210_305 VGND VGND VPWR VPWR sky130_fd_sc_hd__decap_3
XFILLER_0_210_349 VPWR VGND VPWR VGND sky130_ef_sc_hd__decap_12
XPHY_508 VGND VGND VPWR VPWR sky130_fd_sc_hd__decap_3
XPHY_519 VGND VGND VPWR VPWR sky130_fd_sc_hd__decap_3
XFILLER_0_4_1203 VGND VGND VPWR VPWR sky130_fd_sc_hd__fill_1
XPHY_1129 VGND VGND VPWR VPWR sky130_fd_sc_hd__decap_3
XPHY_1118 VGND VGND VPWR VPWR sky130_fd_sc_hd__decap_3
XPHY_1107 VGND VGND VPWR VPWR sky130_fd_sc_hd__decap_3
XFILLER_0_110_1005 VPWR VGND VPWR VGND sky130_ef_sc_hd__decap_12
XFILLER_0_108_309 VPWR VGND VPWR VGND sky130_ef_sc_hd__decap_12
XFILLER_0_188_1275 VGND VGND VPWR VPWR sky130_fd_sc_hd__decap_6
XFILLER_0_202_29 VPWR VGND VPWR VGND sky130_ef_sc_hd__decap_12
XFILLER_0_149_1237 VPWR VGND VPWR VGND sky130_ef_sc_hd__decap_12
XFILLER_0_110_1049 VPWR VGND VPWR VGND sky130_ef_sc_hd__decap_12
XFILLER_0_34_605 VPWR VGND VPWR VGND sky130_ef_sc_hd__decap_12
XFILLER_0_85_1225 VPWR VGND VPWR VGND sky130_ef_sc_hd__decap_12
XFILLER_0_225_1169 VGND VGND VPWR VPWR sky130_fd_sc_hd__decap_6
XFILLER_0_112_581 VGND VGND VPWR VPWR sky130_fd_sc_hd__decap_6
XFILLER_0_195_1213 VPWR VGND VPWR VGND sky130_ef_sc_hd__decap_12
XFILLER_0_61_1291 VPWR VGND VPWR VGND sky130_ef_sc_hd__decap_12
XFILLER_0_22_1275 VGND VGND VPWR VPWR sky130_fd_sc_hd__decap_6
XFILLER_0_195_1279 VPWR VGND VPWR VGND sky130_ef_sc_hd__decap_12
XFILLER_0_96_1343 VGND VGND VPWR VPWR sky130_fd_sc_hd__fill_1
XFILLER_0_214_699 VGND VGND VPWR VPWR sky130_fd_sc_hd__fill_1
XANTENNA_input121_A w01[13] VGND VGND VPWR VPWR sky130_fd_sc_hd__diode_2
XTAP_1222 VGND VPWR sky130_fd_sc_hd__tapvpwrvgnd_1
XFILLER_0_132_1263 VPWR VGND VPWR VGND sky130_ef_sc_hd__decap_12
XTAP_1244 VGND VPWR sky130_fd_sc_hd__tapvpwrvgnd_1
XTAP_1266 VGND VPWR sky130_fd_sc_hd__tapvpwrvgnd_1
XTAP_1233 VGND VPWR sky130_fd_sc_hd__tapvpwrvgnd_1
XTAP_1255 VGND VPWR sky130_fd_sc_hd__tapvpwrvgnd_1
XFILLER_0_127_629 VPWR VGND VPWR VGND sky130_ef_sc_hd__decap_12
XTAP_1299 VGND VPWR sky130_fd_sc_hd__tapvpwrvgnd_1
XTAP_1277 VGND VPWR sky130_fd_sc_hd__tapvpwrvgnd_1
XTAP_1288 VGND VPWR sky130_fd_sc_hd__tapvpwrvgnd_1
XFILLER_0_25_605 VPWR VGND VPWR VGND sky130_ef_sc_hd__decap_12
XFILLER_0_112_29 VPWR VGND VPWR VGND sky130_ef_sc_hd__decap_12
XFILLER_0_92_593 VPWR VGND VPWR VGND sky130_ef_sc_hd__decap_12
XFILLER_0_40_619 VPWR VGND VPWR VGND sky130_ef_sc_hd__decap_12
XFILLER_0_150_643 VPWR VGND VPWR VGND sky130_ef_sc_hd__decap_12
XFILLER_0_225_909 VPWR VGND VPWR VGND sky130_ef_sc_hd__decap_12
XANTENNA_u_pe10_weight_in[1] net140 VGND VGND VPWR VPWR sky130_fd_sc_hd__diode_2
XFILLER_0_40_1331 VGND VGND VPWR VPWR sky130_fd_sc_hd__decap_6
XFILLER_0_218_961 VPWR VGND VPWR VGND sky130_ef_sc_hd__decap_12
XFILLER_0_224_419 VGND VGND VPWR VPWR sky130_fd_sc_hd__fill_1
XFILLER_0_137_15 VPWR VGND VPWR VGND sky130_ef_sc_hd__decap_12
XFILLER_0_174_1319 VPWR VGND VPWR VGND sky130_ef_sc_hd__decap_12
XFILLER_0_220_625 VPWR VGND VPWR VGND sky130_ef_sc_hd__decap_12
XFILLER_0_217_81 VPWR VGND VPWR VGND sky130_ef_sc_hd__decap_12
XFILLER_0_1_37 VPWR VGND VPWR VGND sky130_ef_sc_hd__decap_12
XFILLER_0_220_669 VPWR VGND VPWR VGND sky130_ef_sc_hd__decap_12
XFILLER_0_153_47 VGND VGND VPWR VPWR sky130_fd_sc_hd__decap_3
XTAP_2490 VGND VPWR sky130_fd_sc_hd__tapvpwrvgnd_1
XFILLER_0_141_3 VPWR VGND VPWR VGND sky130_ef_sc_hd__decap_12
XFILLER_0_111_1325 VPWR VGND VPWR VGND sky130_ef_sc_hd__decap_12
XFILLER_0_7_337 VPWR VGND VPWR VGND sky130_ef_sc_hd__decap_12
XFILLER_0_16_605 VPWR VGND VPWR VGND sky130_ef_sc_hd__decap_12
XFILLER_0_83_593 VPWR VGND VPWR VGND sky130_ef_sc_hd__decap_12
XFILLER_0_114_813 VPWR VGND VPWR VGND sky130_ef_sc_hd__decap_12
XFILLER_0_222_1309 VGND VGND VPWR VPWR sky130_fd_sc_hd__decap_6
XFILLER_0_148_1281 VGND VGND VPWR VPWR sky130_fd_sc_hd__fill_1
XFILLER_0_109_1287 VGND VGND VPWR VPWR sky130_fd_sc_hd__fill_1
XFILLER_0_45_1253 VGND VGND VPWR VPWR sky130_fd_sc_hd__fill_1
XFILLER_0_46_3 VPWR VGND VPWR VGND sky130_ef_sc_hd__decap_12
XFILLER_0_223_441 VGND VGND VPWR VPWR sky130_fd_sc_hd__decap_6
XFILLER_0_98_619 VPWR VGND VPWR VGND sky130_ef_sc_hd__decap_12
XFILLER_0_223_485 VPWR VGND VPWR VGND sky130_ef_sc_hd__decap_12
XFILLER_0_210_113 VGND VGND VPWR VPWR sky130_fd_sc_hd__decap_6
XFILLER_0_116_1225 VGND VGND VPWR VPWR sky130_fd_sc_hd__fill_1
XFILLER_0_6_1309 VGND VGND VPWR VPWR sky130_fd_sc_hd__decap_6
XFILLER_0_17_1311 VPWR VGND VPWR VGND sky130_ef_sc_hd__decap_12
XFILLER_0_52_1213 VPWR VGND VPWR VGND sky130_ef_sc_hd__decap_12
XPHY_305 VGND VGND VPWR VPWR sky130_fd_sc_hd__decap_3
XPHY_316 VGND VGND VPWR VPWR sky130_fd_sc_hd__decap_3
XFILLER_0_109_629 VPWR VGND VPWR VGND sky130_ef_sc_hd__decap_12
XPHY_349 VGND VGND VPWR VPWR sky130_fd_sc_hd__decap_3
XPHY_327 VGND VGND VPWR VPWR sky130_fd_sc_hd__decap_3
XPHY_338 VGND VGND VPWR VPWR sky130_fd_sc_hd__decap_3
XFILLER_0_87_1309 VGND VGND VPWR VPWR sky130_fd_sc_hd__fill_1
XFILLER_0_108_139 VGND VGND VPWR VPWR sky130_fd_sc_hd__fill_1
XFILLER_0_74_593 VPWR VGND VPWR VGND sky130_ef_sc_hd__decap_12
XFILLER_0_7_893 VGND VGND VPWR VPWR sky130_fd_sc_hd__decap_3
XFILLER_0_162_1201 VPWR VGND VPWR VGND sky130_ef_sc_hd__decap_12
XFILLER_0_127_1343 VGND VGND VPWR VPWR sky130_fd_sc_hd__fill_1
XFILLER_0_132_643 VPWR VGND VPWR VGND sky130_ef_sc_hd__decap_12
XFILLER_0_22_619 VPWR VGND VPWR VGND sky130_ef_sc_hd__decap_12
XFILLER_0_104_389 VGND VGND VPWR VPWR sky130_fd_sc_hd__decap_3
XFILLER_0_24_1337 VGND VGND VPWR VPWR sky130_fd_sc_hd__fill_1
XFILLER_0_203_1253 VGND VGND VPWR VPWR sky130_fd_sc_hd__fill_1
XFILLER_0_215_953 VPWR VGND VPWR VGND sky130_ef_sc_hd__decap_12
XFILLER_0_16_49 VGND VGND VPWR VPWR sky130_fd_sc_hd__fill_1
XFILLER_0_16_27 VGND VGND VPWR VPWR sky130_fd_sc_hd__fill_1
XFILLER_0_97_641 VGND VGND VPWR VPWR sky130_fd_sc_hd__decap_4
XFILLER_0_32_15 VPWR VGND VPWR VGND sky130_ef_sc_hd__decap_12
XFILLER_0_123_39 VGND VGND VPWR VPWR sky130_fd_sc_hd__decap_8
XFILLER_0_210_1257 VGND VGND VPWR VPWR sky130_fd_sc_hd__decap_3
XPHY_850 VGND VGND VPWR VPWR sky130_fd_sc_hd__decap_3
XPHY_872 VGND VGND VPWR VPWR sky130_fd_sc_hd__decap_3
XPHY_861 VGND VGND VPWR VPWR sky130_fd_sc_hd__decap_3
XPHY_894 VGND VGND VPWR VPWR sky130_fd_sc_hd__decap_3
XPHY_883 VGND VGND VPWR VPWR sky130_fd_sc_hd__decap_3
XFILLER_0_4_307 VGND VGND VPWR VPWR sky130_fd_sc_hd__fill_1
XFILLER_0_65_593 VPWR VGND VPWR VGND sky130_ef_sc_hd__decap_12
XFILLER_0_107_161 VGND VGND VPWR VPWR sky130_fd_sc_hd__decap_6
XFILLER_0_114_109 VGND VGND VPWR VPWR sky130_fd_sc_hd__decap_3
XFILLER_0_29_1237 VPWR VGND VPWR VGND sky130_ef_sc_hd__decap_12
XFILLER_0_68_1275 VGND VGND VPWR VPWR sky130_fd_sc_hd__decap_6
XFILLER_0_21_641 VGND VGND VPWR VPWR sky130_fd_sc_hd__decap_4
XFILLER_0_104_1173 VGND VGND VPWR VPWR sky130_fd_sc_hd__decap_3
XFILLER_0_178_1263 VPWR VGND VPWR VGND sky130_ef_sc_hd__decap_12
XFILLER_0_139_1225 VPWR VGND VPWR VGND sky130_ef_sc_hd__decap_12
XFILLER_0_73_22 VPWR VGND VPWR VGND sky130_ef_sc_hd__decap_12
XFILLER_0_75_1213 VPWR VGND VPWR VGND sky130_ef_sc_hd__decap_12
XFILLER_0_215_1113 VGND VGND VPWR VPWR sky130_fd_sc_hd__decap_6
XFILLER_0_215_1157 VPWR VGND VPWR VGND sky130_ef_sc_hd__decap_12
XFILLER_0_221_945 VGND VGND VPWR VPWR sky130_fd_sc_hd__decap_6
XFILLER_0_220_433 VPWR VGND VPWR VGND sky130_ef_sc_hd__decap_12
XFILLER_0_75_1279 VPWR VGND VPWR VGND sky130_ef_sc_hd__decap_12
XFILLER_0_221_989 VPWR VGND VPWR VGND sky130_ef_sc_hd__decap_12
XFILLER_0_220_477 VPWR VGND VPWR VGND sky130_ef_sc_hd__decap_12
XFILLER_0_185_1201 VPWR VGND VPWR VGND sky130_ef_sc_hd__decap_12
XFILLER_0_115_1291 VPWR VGND VPWR VGND sky130_ef_sc_hd__decap_12
XFILLER_0_111_1133 VPWR VGND VPWR VGND sky130_ef_sc_hd__decap_12
XFILLER_0_111_1177 VPWR VGND VPWR VGND sky130_ef_sc_hd__decap_12
XFILLER_0_56_593 VPWR VGND VPWR VGND sky130_ef_sc_hd__decap_12
XFILLER_0_12_1263 VPWR VGND VPWR VGND sky130_ef_sc_hd__decap_12
XFILLER_0_185_1267 VPWR VGND VPWR VGND sky130_ef_sc_hd__decap_12
XFILLER_0_86_1331 VGND VGND VPWR VPWR sky130_fd_sc_hd__decap_6
XFILLER_0_226_1220 VPWR VGND VPWR VGND sky130_ef_sc_hd__decap_12
XFILLER_0_98_41 VGND VGND VPWR VPWR sky130_fd_sc_hd__decap_8
XFILLER_0_222_1117 VPWR VGND VPWR VGND sky130_ef_sc_hd__decap_12
XFILLER_0_82_1239 VPWR VGND VPWR VGND sky130_ef_sc_hd__decap_12
XFILLER_0_3_373 VPWR VGND VPWR VGND sky130_ef_sc_hd__decap_12
XFILLER_0_122_1251 VPWR VGND VPWR VGND sky130_ef_sc_hd__decap_12
Xinput118 w01[10] VGND VGND VPWR VPWR net118 sky130_fd_sc_hd__buf_4
XFILLER_0_110_893 VPWR VGND VPWR VGND sky130_ef_sc_hd__decap_12
Xinput107 w00[15] VGND VGND VPWR VPWR net107 sky130_fd_sc_hd__buf_1
XFILLER_0_215_205 VPWR VGND VPWR VGND sky130_ef_sc_hd__decap_12
XFILLER_0_157_1303 VGND VGND VPWR VPWR sky130_fd_sc_hd__decap_6
XFILLER_0_122_1295 VPWR VGND VPWR VGND sky130_ef_sc_hd__decap_12
Xinput129 w01[6] VGND VGND VPWR VPWR net129 sky130_fd_sc_hd__buf_4
XFILLER_0_192_1227 VPWR VGND VPWR VGND sky130_ef_sc_hd__decap_12
XFILLER_0_215_249 VPWR VGND VPWR VGND sky130_ef_sc_hd__decap_12
XFILLER_0_212_923 VGND VGND VPWR VPWR sky130_fd_sc_hd__fill_1
XFILLER_0_93_1335 VGND VGND VPWR VPWR sky130_fd_sc_hd__decap_8
XFILLER_0_223_293 VPWR VGND VPWR VGND sky130_ef_sc_hd__decap_12
XFILLER_0_79_641 VGND VGND VPWR VPWR sky130_fd_sc_hd__decap_4
XFILLER_0_54_1319 VPWR VGND VPWR VGND sky130_ef_sc_hd__decap_12
XFILLER_0_6_1117 VPWR VGND VPWR VGND sky130_ef_sc_hd__decap_12
XFILLER_0_94_655 VGND VGND VPWR VPWR sky130_fd_sc_hd__decap_4
XPHY_124 VGND VGND VPWR VPWR sky130_fd_sc_hd__decap_3
XPHY_113 VGND VGND VPWR VPWR sky130_fd_sc_hd__decap_3
XPHY_102 VGND VGND VPWR VPWR sky130_fd_sc_hd__decap_3
XPHY_157 VGND VGND VPWR VPWR sky130_fd_sc_hd__decap_3
XPHY_135 VGND VGND VPWR VPWR sky130_fd_sc_hd__decap_3
XPHY_146 VGND VGND VPWR VPWR sky130_fd_sc_hd__decap_3
XPHY_179 VGND VGND VPWR VPWR sky130_fd_sc_hd__decap_3
XPHY_168 VGND VGND VPWR VPWR sky130_fd_sc_hd__decap_3
XFILLER_0_47_593 VPWR VGND VPWR VGND sky130_ef_sc_hd__decap_12
XFILLER_0_164_1307 VPWR VGND VPWR VGND sky130_ef_sc_hd__decap_12
XFILLER_0_105_665 VGND VGND VPWR VPWR sky130_fd_sc_hd__decap_6
XFILLER_0_104_153 VPWR VGND VPWR VGND sky130_ef_sc_hd__decap_12
XFILLER_0_104_197 VPWR VGND VPWR VGND sky130_ef_sc_hd__decap_12
XFILLER_0_28_1281 VGND VGND VPWR VPWR sky130_fd_sc_hd__fill_1
XFILLER_0_98_1213 VPWR VGND VPWR VGND sky130_ef_sc_hd__decap_12
XFILLER_0_101_1335 VGND VGND VPWR VPWR sky130_fd_sc_hd__fill_1
XFILLER_0_27_15 VPWR VGND VPWR VGND sky130_ef_sc_hd__decap_12
XFILLER_0_175_9 VGND VGND VPWR VPWR sky130_fd_sc_hd__fill_2
XFILLER_0_215_783 VGND VGND VPWR VPWR sky130_fd_sc_hd__fill_1
XFILLER_0_134_27 VGND VGND VPWR VPWR sky130_fd_sc_hd__fill_1
XFILLER_0_43_47 VGND VGND VPWR VPWR sky130_fd_sc_hd__fill_1
XFILLER_0_134_49 VGND VGND VPWR VPWR sky130_fd_sc_hd__fill_1
XPHY_4 VGND VGND VPWR VPWR sky130_fd_sc_hd__decap_3
XFILLER_0_210_1087 VGND VGND VPWR VPWR sky130_fd_sc_hd__fill_1
XFILLER_0_210_1065 VGND VGND VPWR VPWR sky130_fd_sc_hd__decap_8
XFILLER_0_38_593 VPWR VGND VPWR VGND sky130_ef_sc_hd__decap_12
XANTENNA_u_pe11_weight_in[8] net163 VGND VGND VPWR VPWR sky130_fd_sc_hd__diode_2
XPHY_680 VGND VGND VPWR VPWR sky130_fd_sc_hd__decap_3
XPHY_691 VGND VGND VPWR VPWR sky130_fd_sc_hd__decap_3
XFILLER_0_104_3 VPWR VGND VPWR VGND sky130_ef_sc_hd__decap_12
XFILLER_0_7_25 VGND VGND VPWR VPWR sky130_fd_sc_hd__decap_3
XFILLER_0_1_833 VGND VGND VPWR VPWR sky130_fd_sc_hd__decap_6
XFILLER_0_7_69 VPWR VGND VPWR VGND sky130_ef_sc_hd__decap_12
XFILLER_0_42_1201 VPWR VGND VPWR VGND sky130_ef_sc_hd__decap_12
XFILLER_0_1_877 VPWR VGND VPWR VGND sky130_ef_sc_hd__decap_12
XFILLER_0_0_343 VPWR VGND VPWR VGND sky130_ef_sc_hd__decap_12
XFILLER_0_0_365 VPWR VGND VPWR VGND sky130_ef_sc_hd__decap_12
XFILLER_0_110_189 VGND VGND VPWR VPWR sky130_fd_sc_hd__decap_6
XFILLER_0_225_503 VGND VGND VPWR VPWR sky130_fd_sc_hd__fill_1
XFILLER_0_175_45 VGND VGND VPWR VPWR sky130_fd_sc_hd__decap_3
XFILLER_0_84_10 VPWR VGND VPWR VGND sky130_ef_sc_hd__decap_12
XFILLER_0_213_709 VPWR VGND VPWR VGND sky130_ef_sc_hd__decap_12
XFILLER_0_108_83 VGND VGND VPWR VPWR sky130_fd_sc_hd__fill_1
XFILLER_0_221_753 VPWR VGND VPWR VGND sky130_ef_sc_hd__decap_12
XFILLER_0_221_797 VPWR VGND VPWR VGND sky130_ef_sc_hd__decap_12
XFILLER_0_193_605 VPWR VGND VPWR VGND sky130_ef_sc_hd__decap_12
XFILLER_0_76_655 VGND VGND VPWR VPWR sky130_fd_sc_hd__decap_4
XFILLER_0_91_647 VPWR VGND VPWR VGND sky130_ef_sc_hd__decap_12
XFILLER_0_29_593 VPWR VGND VPWR VGND sky130_ef_sc_hd__decap_12
XFILLER_0_210_29 VPWR VGND VPWR VGND sky130_ef_sc_hd__decap_12
XFILLER_0_3_181 VPWR VGND VPWR VGND sky130_ef_sc_hd__decap_12
XFILLER_0_4_693 VGND VGND VPWR VPWR sky130_fd_sc_hd__decap_6
XFILLER_0_114_473 VGND VGND VPWR VPWR sky130_fd_sc_hd__decap_3
XFILLER_0_200_1201 VPWR VGND VPWR VGND sky130_ef_sc_hd__decap_12
XFILLER_0_219_27 VPWR VGND VPWR VGND sky130_ef_sc_hd__decap_12
XFILLER_0_216_525 VGND VGND VPWR VPWR sky130_fd_sc_hd__decap_6
XFILLER_0_216_569 VPWR VGND VPWR VGND sky130_ef_sc_hd__decap_12
XFILLER_0_19_1225 VPWR VGND VPWR VGND sky130_ef_sc_hd__decap_12
XFILLER_0_58_1263 VPWR VGND VPWR VGND sky130_ef_sc_hd__decap_12
XFILLER_0_184_605 VPWR VGND VPWR VGND sky130_ef_sc_hd__decap_12
XFILLER_0_13_39 VGND VGND VPWR VPWR sky130_fd_sc_hd__decap_8
XFILLER_0_67_655 VGND VGND VPWR VPWR sky130_fd_sc_hd__fill_2
XFILLER_0_109_223 VGND VGND VPWR VPWR sky130_fd_sc_hd__fill_1
XANTENNA_input97_A psum_col1_in[9] VGND VGND VPWR VPWR sky130_fd_sc_hd__diode_2
XFILLER_0_168_1251 VPWR VGND VPWR VGND sky130_ef_sc_hd__decap_12
XFILLER_0_129_1213 VPWR VGND VPWR VGND sky130_ef_sc_hd__decap_12
XFILLER_0_168_1295 VPWR VGND VPWR VGND sky130_ef_sc_hd__decap_12
XFILLER_0_65_1201 VPWR VGND VPWR VGND sky130_ef_sc_hd__decap_12
XFILLER_0_120_29 VPWR VGND VPWR VGND sky130_ef_sc_hd__decap_12
XFILLER_0_129_1279 VPWR VGND VPWR VGND sky130_ef_sc_hd__decap_12
XFILLER_0_65_1267 VPWR VGND VPWR VGND sky130_ef_sc_hd__decap_12
XFILLER_0_105_473 VPWR VGND VPWR VGND sky130_ef_sc_hd__decap_12
XFILLER_0_38_25 VGND VGND VPWR VPWR sky130_fd_sc_hd__decap_3
XFILLER_0_219_385 VGND VGND VPWR VPWR sky130_fd_sc_hd__decap_6
XFILLER_0_175_1255 VPWR VGND VPWR VGND sky130_ef_sc_hd__decap_12
XFILLER_0_145_15 VPWR VGND VPWR VGND sky130_ef_sc_hd__decap_12
XFILLER_0_136_1239 VPWR VGND VPWR VGND sky130_ef_sc_hd__decap_12
XFILLER_0_37_1303 VGND VGND VPWR VPWR sky130_fd_sc_hd__decap_6
XFILLER_0_216_1241 VPWR VGND VPWR VGND sky130_ef_sc_hd__decap_12
XFILLER_0_72_1227 VPWR VGND VPWR VGND sky130_ef_sc_hd__decap_12
XFILLER_0_216_1285 VPWR VGND VPWR VGND sky130_ef_sc_hd__decap_12
XFILLER_0_212_1105 VPWR VGND VPWR VGND sky130_ef_sc_hd__decap_12
XFILLER_0_175_605 VPWR VGND VPWR VGND sky130_ef_sc_hd__decap_12
XFILLER_0_225_81 VPWR VGND VPWR VGND sky130_ef_sc_hd__decap_12
XFILLER_0_212_1149 VPWR VGND VPWR VGND sky130_ef_sc_hd__decap_12
XFILLER_0_58_655 VGND VGND VPWR VPWR sky130_fd_sc_hd__decap_4
XFILLER_0_190_619 VPWR VGND VPWR VGND sky130_ef_sc_hd__decap_12
XFILLER_0_221_3 VPWR VGND VPWR VGND sky130_ef_sc_hd__decap_12
XFILLER_0_112_1261 VPWR VGND VPWR VGND sky130_ef_sc_hd__decap_12
XFILLER_0_6_925 VPWR VGND VPWR VGND sky130_ef_sc_hd__decap_12
XFILLER_0_73_647 VGND VGND VPWR VPWR sky130_fd_sc_hd__decap_8
XFILLER_0_147_1335 VGND VGND VPWR VPWR sky130_fd_sc_hd__decap_8
XANTENNA_u_pe11_weight_in[10] net150 VGND VGND VPWR VPWR sky130_fd_sc_hd__diode_2
XANTENNA_u_pe01_psum_in[24] net82 VGND VGND VPWR VPWR sky130_fd_sc_hd__diode_2
XFILLER_0_0_1091 VGND VGND VPWR VPWR sky130_fd_sc_hd__fill_1
XFILLER_0_83_1323 VPWR VGND VPWR VGND sky130_ef_sc_hd__decap_12
XFILLER_0_223_1201 VPWR VGND VPWR VGND sky130_ef_sc_hd__decap_12
XFILLER_0_44_1307 VPWR VGND VPWR VGND sky130_ef_sc_hd__decap_12
XFILLER_0_223_1245 VPWR VGND VPWR VGND sky130_ef_sc_hd__decap_12
XFILLER_0_1_641 VPWR VGND VPWR VGND sky130_ef_sc_hd__decap_12
XFILLER_0_223_1289 VPWR VGND VPWR VGND sky130_ef_sc_hd__decap_12
XFILLER_0_1_685 VPWR VGND VPWR VGND sky130_ef_sc_hd__decap_12
XFILLER_0_193_1311 VPWR VGND VPWR VGND sky130_ef_sc_hd__decap_12
XFILLER_0_226_856 VGND VGND VPWR VPWR sky130_fd_sc_hd__decap_3
XFILLER_0_213_517 VPWR VGND VPWR VGND sky130_ef_sc_hd__decap_12
XTAP_2308 VGND VPWR sky130_fd_sc_hd__tapvpwrvgnd_1
XFILLER_0_154_1339 VGND VGND VPWR VPWR sky130_fd_sc_hd__decap_4
XTAP_2319 VGND VPWR sky130_fd_sc_hd__tapvpwrvgnd_1
XFILLER_0_7_1201 VGND VGND VPWR VPWR sky130_fd_sc_hd__decap_3
XFILLER_0_221_561 VPWR VGND VPWR VGND sky130_ef_sc_hd__decap_12
XFILLER_0_166_605 VPWR VGND VPWR VGND sky130_ef_sc_hd__decap_12
XTAP_1629 VGND VPWR sky130_fd_sc_hd__tapvpwrvgnd_1
XTAP_1618 VGND VPWR sky130_fd_sc_hd__tapvpwrvgnd_1
XFILLER_0_7_1245 VPWR VGND VPWR VGND sky130_ef_sc_hd__decap_12
XTAP_1607 VGND VPWR sky130_fd_sc_hd__tapvpwrvgnd_1
XFILLER_0_49_655 VGND VGND VPWR VPWR sky130_fd_sc_hd__fill_2
XFILLER_0_88_1201 VPWR VGND VPWR VGND sky130_ef_sc_hd__decap_12
XFILLER_0_7_1289 VPWR VGND VPWR VGND sky130_ef_sc_hd__decap_12
XFILLER_0_221_39 VPWR VGND VPWR VGND sky130_ef_sc_hd__decap_12
XFILLER_0_107_727 VGND VGND VPWR VPWR sky130_fd_sc_hd__fill_1
XFILLER_0_202_1307 VPWR VGND VPWR VGND sky130_ef_sc_hd__decap_12
XFILLER_0_114_281 VPWR VGND VPWR VGND sky130_ef_sc_hd__decap_12
XANTENNA_input151_A w11[11] VGND VGND VPWR VPWR sky130_fd_sc_hd__diode_2
XFILLER_0_216_333 VPWR VGND VPWR VGND sky130_ef_sc_hd__decap_12
XFILLER_0_217_889 VGND VGND VPWR VPWR sky130_fd_sc_hd__decap_6
XFILLER_0_216_377 VPWR VGND VPWR VGND sky130_ef_sc_hd__decap_12
XFILLER_0_95_1249 VGND VGND VPWR VPWR sky130_fd_sc_hd__decap_4
XTAP_2820 VGND VPWR sky130_fd_sc_hd__tapvpwrvgnd_1
XANTENNA_input12_A act_row0_in[5] VGND VGND VPWR VPWR sky130_fd_sc_hd__diode_2
XTAP_2864 VGND VPWR sky130_fd_sc_hd__tapvpwrvgnd_1
XTAP_2842 VGND VPWR sky130_fd_sc_hd__tapvpwrvgnd_1
XTAP_2831 VGND VPWR sky130_fd_sc_hd__tapvpwrvgnd_1
XTAP_2853 VGND VPWR sky130_fd_sc_hd__tapvpwrvgnd_1
XFILLER_0_157_605 VPWR VGND VPWR VGND sky130_ef_sc_hd__decap_12
XFILLER_0_24_49 VGND VGND VPWR VPWR sky130_fd_sc_hd__fill_1
XTAP_2886 VGND VPWR sky130_fd_sc_hd__tapvpwrvgnd_1
XTAP_2875 VGND VPWR sky130_fd_sc_hd__tapvpwrvgnd_1
XTAP_2897 VGND VPWR sky130_fd_sc_hd__tapvpwrvgnd_1
XFILLER_0_172_619 VPWR VGND VPWR VGND sky130_ef_sc_hd__decap_12
XFILLER_0_40_15 VPWR VGND VPWR VGND sky130_ef_sc_hd__decap_12
XFILLER_0_55_647 VGND VGND VPWR VPWR sky130_fd_sc_hd__decap_8
XFILLER_0_131_39 VGND VGND VPWR VPWR sky130_fd_sc_hd__decap_8
XFILLER_0_70_617 VGND VGND VPWR VPWR sky130_fd_sc_hd__fill_1
XFILLER_0_106_793 VPWR VGND VPWR VGND sky130_ef_sc_hd__decap_12
Xoutput208 net208 VGND VGND VPWR VPWR psum_col1_out[1] sky130_fd_sc_hd__clkbuf_4
Xoutput219 net219 VGND VGND VPWR VPWR psum_col1_out[2] sky130_fd_sc_hd__clkbuf_4
XFILLER_0_49_13 VPWR VGND VPWR VGND sky130_ef_sc_hd__decap_12
XFILLER_0_105_281 VPWR VGND VPWR VGND sky130_ef_sc_hd__decap_12
XFILLER_0_103_1249 VGND VGND VPWR VPWR sky130_fd_sc_hd__decap_4
XFILLER_0_4_15 VPWR VGND VPWR VGND sky130_ef_sc_hd__decap_12
XFILLER_0_219_193 VPWR VGND VPWR VGND sky130_ef_sc_hd__decap_12
XFILLER_0_114_1301 VPWR VGND VPWR VGND sky130_ef_sc_hd__decap_12
XFILLER_0_148_605 VPWR VGND VPWR VGND sky130_ef_sc_hd__decap_12
XFILLER_0_216_1093 VPWR VGND VPWR VGND sky130_ef_sc_hd__decap_12
XFILLER_0_112_1091 VGND VGND VPWR VPWR sky130_fd_sc_hd__fill_1
XFILLER_0_171_641 VGND VGND VPWR VPWR sky130_fd_sc_hd__decap_4
XFILLER_0_61_617 VPWR VGND VPWR VGND sky130_ef_sc_hd__decap_12
XFILLER_0_108_1105 VPWR VGND VPWR VGND sky130_ef_sc_hd__decap_12
XFILLER_0_6_755 VGND VGND VPWR VPWR sky130_fd_sc_hd__fill_1
XFILLER_0_2_1197 VGND VGND VPWR VPWR sky130_fd_sc_hd__decap_6
XFILLER_0_48_1251 VPWR VGND VPWR VGND sky130_ef_sc_hd__decap_12
XFILLER_0_108_1149 VPWR VGND VPWR VGND sky130_ef_sc_hd__decap_12
XFILLER_0_76_3 VPWR VGND VPWR VGND sky130_ef_sc_hd__decap_12
XFILLER_0_2_961 VPWR VGND VPWR VGND sky130_ef_sc_hd__decap_12
XFILLER_0_48_1295 VPWR VGND VPWR VGND sky130_ef_sc_hd__decap_12
XFILLER_0_160_1343 VGND VGND VPWR VPWR sky130_fd_sc_hd__fill_1
XFILLER_0_111_273 VGND VGND VPWR VPWR sky130_fd_sc_hd__decap_6
XANTENNA_input4_A act_row0_in[12] VGND VGND VPWR VPWR sky130_fd_sc_hd__diode_2
XFILLER_0_214_837 VPWR VGND VPWR VGND sky130_ef_sc_hd__decap_12
XFILLER_0_158_1283 VPWR VGND VPWR VGND sky130_ef_sc_hd__decap_12
XFILLER_0_119_1201 VPWR VGND VPWR VGND sky130_ef_sc_hd__decap_12
XFILLER_0_119_1267 VPWR VGND VPWR VGND sky130_ef_sc_hd__decap_12
XTAP_2116 VGND VPWR sky130_fd_sc_hd__tapvpwrvgnd_1
XTAP_2105 VGND VPWR sky130_fd_sc_hd__tapvpwrvgnd_1
XFILLER_0_222_881 VPWR VGND VPWR VGND sky130_ef_sc_hd__decap_12
XTAP_2149 VGND VPWR sky130_fd_sc_hd__tapvpwrvgnd_1
XTAP_2138 VGND VPWR sky130_fd_sc_hd__tapvpwrvgnd_1
XFILLER_0_139_605 VPWR VGND VPWR VGND sky130_ef_sc_hd__decap_12
XTAP_2127 VGND VPWR sky130_fd_sc_hd__tapvpwrvgnd_1
XTAP_1415 VGND VPWR sky130_fd_sc_hd__tapvpwrvgnd_1
XTAP_1404 VGND VPWR sky130_fd_sc_hd__tapvpwrvgnd_1
XFILLER_0_55_1255 VPWR VGND VPWR VGND sky130_ef_sc_hd__decap_12
XFILLER_0_221_391 VGND VGND VPWR VPWR sky130_fd_sc_hd__fill_1
XTAP_1426 VGND VPWR sky130_fd_sc_hd__tapvpwrvgnd_1
XTAP_1437 VGND VPWR sky130_fd_sc_hd__tapvpwrvgnd_1
XTAP_1448 VGND VPWR sky130_fd_sc_hd__tapvpwrvgnd_1
XFILLER_0_16_1239 VPWR VGND VPWR VGND sky130_ef_sc_hd__decap_12
XTAP_1459 VGND VPWR sky130_fd_sc_hd__tapvpwrvgnd_1
XFILLER_0_154_619 VPWR VGND VPWR VGND sky130_ef_sc_hd__decap_12
XFILLER_0_37_647 VGND VGND VPWR VPWR sky130_fd_sc_hd__decap_8
XFILLER_0_9_593 VPWR VGND VPWR VGND sky130_ef_sc_hd__decap_12
XFILLER_0_52_617 VGND VGND VPWR VPWR sky130_fd_sc_hd__fill_1
XFILLER_0_126_1227 VPWR VGND VPWR VGND sky130_ef_sc_hd__decap_12
XFILLER_0_10_29 VPWR VGND VPWR VGND sky130_ef_sc_hd__decap_12
XFILLER_0_206_1251 VPWR VGND VPWR VGND sky130_ef_sc_hd__decap_12
XFILLER_0_27_1335 VGND VGND VPWR VPWR sky130_fd_sc_hd__decap_8
XFILLER_0_206_1295 VPWR VGND VPWR VGND sky130_ef_sc_hd__decap_12
XFILLER_0_130_593 VPWR VGND VPWR VGND sky130_ef_sc_hd__decap_12
XFILLER_0_19_27 VPWR VGND VPWR VGND sky130_ef_sc_hd__decap_12
XFILLER_0_217_653 VPWR VGND VPWR VGND sky130_ef_sc_hd__decap_12
XFILLER_0_216_141 VPWR VGND VPWR VGND sky130_ef_sc_hd__decap_12
XFILLER_0_217_697 VPWR VGND VPWR VGND sky130_ef_sc_hd__decap_12
XFILLER_0_137_1323 VPWR VGND VPWR VGND sky130_ef_sc_hd__decap_12
XFILLER_0_172_1225 VGND VGND VPWR VPWR sky130_fd_sc_hd__fill_1
XFILLER_0_35_37 VGND VGND VPWR VPWR sky130_fd_sc_hd__decap_8
XFILLER_0_73_1311 VPWR VGND VPWR VGND sky130_ef_sc_hd__decap_12
XANTENNA_output216_A net216 VGND VGND VPWR VPWR sky130_fd_sc_hd__diode_2
XTAP_2661 VGND VPWR sky130_fd_sc_hd__tapvpwrvgnd_1
XFILLER_0_213_1233 VPWR VGND VPWR VGND sky130_ef_sc_hd__decap_12
XTAP_2650 VGND VPWR sky130_fd_sc_hd__tapvpwrvgnd_1
XTAP_2672 VGND VPWR sky130_fd_sc_hd__tapvpwrvgnd_1
XFILLER_0_197_593 VPWR VGND VPWR VGND sky130_ef_sc_hd__decap_12
XFILLER_0_34_1339 VGND VGND VPWR VPWR sky130_fd_sc_hd__decap_4
XTAP_2683 VGND VPWR sky130_fd_sc_hd__tapvpwrvgnd_1
XTAP_2694 VGND VPWR sky130_fd_sc_hd__tapvpwrvgnd_1
XTAP_1960 VGND VPWR sky130_fd_sc_hd__tapvpwrvgnd_1
XFILLER_0_136_6 VGND VGND VPWR VPWR sky130_fd_sc_hd__fill_2
XFILLER_0_142_27 VGND VGND VPWR VPWR sky130_fd_sc_hd__fill_1
XFILLER_0_142_49 VGND VGND VPWR VPWR sky130_fd_sc_hd__fill_1
XTAP_1993 VGND VPWR sky130_fd_sc_hd__tapvpwrvgnd_1
XTAP_1971 VGND VPWR sky130_fd_sc_hd__tapvpwrvgnd_1
XFILLER_0_51_47 VGND VGND VPWR VPWR sky130_fd_sc_hd__fill_1
XTAP_1982 VGND VPWR sky130_fd_sc_hd__tapvpwrvgnd_1
XFILLER_0_43_617 VPWR VGND VPWR VGND sky130_ef_sc_hd__decap_12
XFILLER_0_153_641 VGND VGND VPWR VPWR sky130_fd_sc_hd__decap_4
XFILLER_0_113_505 VPWR VGND VPWR VGND sky130_ef_sc_hd__decap_12
XFILLER_0_183_1343 VGND VGND VPWR VPWR sky130_fd_sc_hd__fill_1
XFILLER_0_80_1337 VGND VGND VPWR VPWR sky130_fd_sc_hd__fill_1
XFILLER_0_121_593 VPWR VGND VPWR VGND sky130_ef_sc_hd__decap_12
XFILLER_0_220_1259 VGND VGND VPWR VPWR sky130_fd_sc_hd__fill_1
XFILLER_0_208_631 VPWR VGND VPWR VGND sky130_ef_sc_hd__decap_12
XFILLER_0_222_133 VGND VGND VPWR VPWR sky130_fd_sc_hd__decap_6
XFILLER_0_222_177 VPWR VGND VPWR VGND sky130_ef_sc_hd__decap_12
XFILLER_0_151_1309 VGND VGND VPWR VPWR sky130_fd_sc_hd__fill_1
XFILLER_0_188_593 VPWR VGND VPWR VGND sky130_ef_sc_hd__decap_12
XPHY_509 VGND VGND VPWR VPWR sky130_fd_sc_hd__decap_3
XPHY_1108 VGND VGND VPWR VPWR sky130_fd_sc_hd__decap_3
XPHY_1119 VGND VGND VPWR VPWR sky130_fd_sc_hd__decap_3
XFILLER_0_110_1017 VPWR VGND VPWR VGND sky130_ef_sc_hd__decap_12
XFILLER_0_136_619 VPWR VGND VPWR VGND sky130_ef_sc_hd__decap_12
XFILLER_0_19_647 VPWR VGND VPWR VGND sky130_ef_sc_hd__decap_12
XFILLER_0_4_1259 VGND VGND VPWR VPWR sky130_fd_sc_hd__fill_1
XFILLER_0_34_617 VGND VGND VPWR VPWR sky130_fd_sc_hd__fill_1
XFILLER_0_149_1249 VGND VGND VPWR VPWR sky130_fd_sc_hd__decap_4
XFILLER_0_85_1237 VPWR VGND VPWR VGND sky130_ef_sc_hd__decap_12
XFILLER_0_104_505 VPWR VGND VPWR VGND sky130_ef_sc_hd__decap_12
XFILLER_0_195_1225 VPWR VGND VPWR VGND sky130_ef_sc_hd__decap_12
XFILLER_0_214_601 VPWR VGND VPWR VGND sky130_ef_sc_hd__decap_12
XFILLER_0_226_461 VGND VGND VPWR VPWR sky130_fd_sc_hd__fill_2
XFILLER_0_214_645 VPWR VGND VPWR VGND sky130_ef_sc_hd__decap_12
XFILLER_0_213_111 VGND VGND VPWR VPWR sky130_fd_sc_hd__fill_1
XTAP_1223 VGND VPWR sky130_fd_sc_hd__tapvpwrvgnd_1
XANTENNA_input114_A w00[7] VGND VGND VPWR VPWR sky130_fd_sc_hd__diode_2
XFILLER_0_179_593 VPWR VGND VPWR VGND sky130_ef_sc_hd__decap_12
XFILLER_0_171_1291 VPWR VGND VPWR VGND sky130_ef_sc_hd__decap_12
XTAP_1245 VGND VPWR sky130_fd_sc_hd__tapvpwrvgnd_1
XTAP_1234 VGND VPWR sky130_fd_sc_hd__tapvpwrvgnd_1
XTAP_1256 VGND VPWR sky130_fd_sc_hd__tapvpwrvgnd_1
XFILLER_0_210_895 VGND VGND VPWR VPWR sky130_fd_sc_hd__fill_1
XFILLER_0_132_1275 VGND VGND VPWR VPWR sky130_fd_sc_hd__decap_6
XFILLER_0_108_811 VGND VGND VPWR VPWR sky130_fd_sc_hd__fill_1
XTAP_1278 VGND VPWR sky130_fd_sc_hd__tapvpwrvgnd_1
XTAP_1267 VGND VPWR sky130_fd_sc_hd__tapvpwrvgnd_1
XTAP_1289 VGND VPWR sky130_fd_sc_hd__tapvpwrvgnd_1
XFILLER_0_25_617 VPWR VGND VPWR VGND sky130_ef_sc_hd__decap_12
XFILLER_0_135_641 VGND VGND VPWR VPWR sky130_fd_sc_hd__decap_4
XFILLER_0_150_655 VGND VGND VPWR VPWR sky130_fd_sc_hd__decap_4
XFILLER_0_103_593 VPWR VGND VPWR VGND sky130_ef_sc_hd__decap_12
XANTENNA_u_pe10_weight_in[0] net133 VGND VGND VPWR VPWR sky130_fd_sc_hd__diode_2
XFILLER_0_218_973 VGND VGND VPWR VPWR sky130_fd_sc_hd__decap_6
XFILLER_0_40_1343 VGND VGND VPWR VPWR sky130_fd_sc_hd__fill_1
XFILLER_0_137_27 VPWR VGND VPWR VGND sky130_ef_sc_hd__decap_12
XFILLER_0_217_461 VPWR VGND VPWR VGND sky130_ef_sc_hd__decap_12
XFILLER_0_205_645 VGND VGND VPWR VPWR sky130_fd_sc_hd__fill_1
XFILLER_0_217_93 VPWR VGND VPWR VGND sky130_ef_sc_hd__decap_12
XFILLER_0_153_15 VPWR VGND VPWR VGND sky130_ef_sc_hd__decap_12
XFILLER_0_220_637 VGND VGND VPWR VPWR sky130_fd_sc_hd__decap_6
XFILLER_0_1_49 VGND VGND VPWR VPWR sky130_fd_sc_hd__decap_6
XFILLER_0_38_1283 VPWR VGND VPWR VGND sky130_ef_sc_hd__decap_12
XFILLER_0_213_1063 VGND VGND VPWR VPWR sky130_fd_sc_hd__fill_1
XTAP_2480 VGND VPWR sky130_fd_sc_hd__tapvpwrvgnd_1
XFILLER_0_150_1331 VGND VGND VPWR VPWR sky130_fd_sc_hd__decap_6
XTAP_2491 VGND VPWR sky130_fd_sc_hd__tapvpwrvgnd_1
XFILLER_0_111_1337 VGND VGND VPWR VPWR sky130_fd_sc_hd__decap_6
XFILLER_0_118_619 VPWR VGND VPWR VGND sky130_ef_sc_hd__decap_12
XFILLER_0_7_305 VGND VGND VPWR VPWR sky130_fd_sc_hd__decap_3
XFILLER_0_134_3 VPWR VGND VPWR VGND sky130_ef_sc_hd__decap_12
XTAP_1790 VGND VPWR sky130_fd_sc_hd__tapvpwrvgnd_1
XFILLER_0_16_617 VGND VGND VPWR VPWR sky130_fd_sc_hd__fill_1
XFILLER_0_7_349 VPWR VGND VPWR VGND sky130_ef_sc_hd__decap_12
XFILLER_0_3_1281 VGND VGND VPWR VPWR sky130_fd_sc_hd__decap_6
XFILLER_0_114_825 VPWR VGND VPWR VGND sky130_ef_sc_hd__decap_12
XFILLER_0_102_41 VGND VGND VPWR VPWR sky130_fd_sc_hd__decap_8
XFILLER_0_109_1233 VPWR VGND VPWR VGND sky130_ef_sc_hd__decap_12
XFILLER_0_141_655 VGND VGND VPWR VPWR sky130_fd_sc_hd__fill_2
XFILLER_0_114_869 VPWR VGND VPWR VGND sky130_ef_sc_hd__decap_12
XFILLER_0_113_335 VGND VGND VPWR VPWR sky130_fd_sc_hd__fill_1
XFILLER_0_105_1119 VGND VGND VPWR VPWR sky130_fd_sc_hd__fill_1
XFILLER_0_87_10 VPWR VGND VPWR VGND sky130_ef_sc_hd__decap_12
XFILLER_0_84_1281 VGND VGND VPWR VPWR sky130_fd_sc_hd__fill_1
XFILLER_0_39_3 VPWR VGND VPWR VGND sky130_ef_sc_hd__decap_12
XFILLER_0_211_615 VGND VGND VPWR VPWR sky130_fd_sc_hd__fill_1
XFILLER_0_155_1253 VGND VGND VPWR VPWR sky130_fd_sc_hd__fill_1
XFILLER_0_223_497 VGND VGND VPWR VPWR sky130_fd_sc_hd__decap_6
XFILLER_0_210_103 VGND VGND VPWR VPWR sky130_fd_sc_hd__fill_1
XFILLER_0_17_1323 VGND VGND VPWR VPWR sky130_fd_sc_hd__fill_1
XFILLER_0_210_169 VPWR VGND VPWR VGND sky130_ef_sc_hd__decap_12
XFILLER_0_210_136 VGND VGND VPWR VPWR sky130_fd_sc_hd__decap_4
XPHY_306 VGND VGND VPWR VPWR sky130_fd_sc_hd__decap_3
XFILLER_0_52_1225 VGND VGND VPWR VPWR sky130_fd_sc_hd__fill_1
XPHY_328 VGND VGND VPWR VPWR sky130_fd_sc_hd__decap_3
XPHY_317 VGND VGND VPWR VPWR sky130_fd_sc_hd__decap_3
XPHY_339 VGND VGND VPWR VPWR sky130_fd_sc_hd__decap_3
XFILLER_0_117_641 VGND VGND VPWR VPWR sky130_fd_sc_hd__decap_4
XFILLER_0_127_1311 VPWR VGND VPWR VGND sky130_ef_sc_hd__decap_12
XFILLER_0_162_1213 VPWR VGND VPWR VGND sky130_ef_sc_hd__decap_12
XFILLER_0_132_655 VGND VGND VPWR VPWR sky130_fd_sc_hd__decap_4
XFILLER_0_30_631 VPWR VGND VPWR VGND sky130_ef_sc_hd__decap_12
XFILLER_0_63_1343 VGND VGND VPWR VPWR sky130_fd_sc_hd__fill_1
XFILLER_0_197_1309 VGND VGND VPWR VPWR sky130_fd_sc_hd__fill_1
XFILLER_0_215_921 VPWR VGND VPWR VGND sky130_ef_sc_hd__decap_12
XFILLER_0_215_965 VPWR VGND VPWR VGND sky130_ef_sc_hd__decap_12
XFILLER_0_214_475 VGND VGND VPWR VPWR sky130_fd_sc_hd__fill_1
XFILLER_0_134_1337 VGND VGND VPWR VPWR sky130_fd_sc_hd__fill_1
XFILLER_0_32_27 VGND VGND VPWR VPWR sky130_fd_sc_hd__fill_1
XFILLER_0_31_1309 VGND VGND VPWR VPWR sky130_fd_sc_hd__fill_1
XPHY_840 VGND VGND VPWR VPWR sky130_fd_sc_hd__decap_3
XPHY_862 VGND VGND VPWR VPWR sky130_fd_sc_hd__decap_3
XPHY_851 VGND VGND VPWR VPWR sky130_fd_sc_hd__decap_3
XFILLER_0_32_49 VGND VGND VPWR VPWR sky130_fd_sc_hd__fill_1
XPHY_895 VGND VGND VPWR VPWR sky130_fd_sc_hd__decap_3
XFILLER_0_5_809 VPWR VGND VPWR VGND sky130_ef_sc_hd__decap_12
XPHY_873 VGND VGND VPWR VPWR sky130_fd_sc_hd__decap_3
XPHY_884 VGND VGND VPWR VPWR sky130_fd_sc_hd__decap_3
XFILLER_0_29_1249 VGND VGND VPWR VPWR sky130_fd_sc_hd__decap_4
XFILLER_0_111_839 VGND VGND VPWR VPWR sky130_fd_sc_hd__fill_1
XFILLER_0_148_15 VPWR VGND VPWR VGND sky130_ef_sc_hd__decap_12
XFILLER_0_178_1275 VGND VGND VPWR VPWR sky130_fd_sc_hd__decap_6
XFILLER_0_225_729 VPWR VGND VPWR VGND sky130_ef_sc_hd__decap_12
XFILLER_0_218_781 VPWR VGND VPWR VGND sky130_ef_sc_hd__decap_12
XFILLER_0_139_1237 VPWR VGND VPWR VGND sky130_ef_sc_hd__decap_12
XFILLER_0_220_401 VPWR VGND VPWR VGND sky130_ef_sc_hd__decap_12
XFILLER_0_73_34 VPWR VGND VPWR VGND sky130_ef_sc_hd__decap_12
XFILLER_0_75_1225 VPWR VGND VPWR VGND sky130_ef_sc_hd__decap_12
XFILLER_0_88_631 VPWR VGND VPWR VGND sky130_ef_sc_hd__decap_12
XFILLER_0_215_1169 VGND VGND VPWR VPWR sky130_fd_sc_hd__decap_6
XFILLER_0_220_445 VPWR VGND VPWR VGND sky130_ef_sc_hd__decap_12
XFILLER_0_220_489 VPWR VGND VPWR VGND sky130_ef_sc_hd__decap_12
XFILLER_0_111_1101 VPWR VGND VPWR VGND sky130_ef_sc_hd__decap_12
XFILLER_0_5_1343 VGND VGND VPWR VPWR sky130_fd_sc_hd__fill_1
XFILLER_0_111_1145 VPWR VGND VPWR VGND sky130_ef_sc_hd__decap_12
XFILLER_0_7_113 VPWR VGND VPWR VGND sky130_ef_sc_hd__decap_12
XFILLER_0_185_1213 VPWR VGND VPWR VGND sky130_ef_sc_hd__decap_12
XFILLER_0_51_1291 VPWR VGND VPWR VGND sky130_ef_sc_hd__decap_12
XFILLER_0_113_51 VGND VGND VPWR VPWR sky130_fd_sc_hd__decap_4
XFILLER_0_111_1189 VPWR VGND VPWR VGND sky130_ef_sc_hd__decap_12
XFILLER_0_12_1275 VGND VGND VPWR VPWR sky130_fd_sc_hd__decap_6
XFILLER_0_86_1343 VGND VGND VPWR VPWR sky130_fd_sc_hd__fill_1
XFILLER_0_226_1243 VGND VGND VPWR VPWR sky130_fd_sc_hd__fill_2
XFILLER_0_185_1279 VPWR VGND VPWR VGND sky130_ef_sc_hd__decap_12
XFILLER_0_109_1063 VGND VGND VPWR VPWR sky130_fd_sc_hd__fill_1
XFILLER_0_12_631 VPWR VGND VPWR VGND sky130_ef_sc_hd__decap_12
XFILLER_0_222_1129 VPWR VGND VPWR VGND sky130_ef_sc_hd__decap_12
XFILLER_0_3_385 VGND VGND VPWR VPWR sky130_fd_sc_hd__decap_6
XFILLER_0_110_861 VGND VGND VPWR VPWR sky130_fd_sc_hd__decap_6
XFILLER_0_196_1331 VGND VGND VPWR VPWR sky130_fd_sc_hd__decap_6
XFILLER_0_122_1263 VPWR VGND VPWR VGND sky130_ef_sc_hd__decap_12
Xinput108 w00[1] VGND VGND VPWR VPWR net108 sky130_fd_sc_hd__buf_1
XFILLER_0_215_217 VGND VGND VPWR VPWR sky130_fd_sc_hd__decap_6
XFILLER_0_208_29 VPWR VGND VPWR VGND sky130_ef_sc_hd__decap_12
Xinput119 w01[11] VGND VGND VPWR VPWR net119 sky130_fd_sc_hd__clkbuf_4
XFILLER_0_93_1303 VGND VGND VPWR VPWR sky130_fd_sc_hd__decap_6
XFILLER_0_192_1239 VPWR VGND VPWR VGND sky130_ef_sc_hd__decap_12
XFILLER_0_223_261 VPWR VGND VPWR VGND sky130_ef_sc_hd__decap_12
XFILLER_0_212_979 VGND VGND VPWR VPWR sky130_fd_sc_hd__fill_1
XFILLER_0_6_1129 VPWR VGND VPWR VGND sky130_ef_sc_hd__decap_12
XPHY_125 VGND VGND VPWR VPWR sky130_fd_sc_hd__decap_3
XPHY_103 VGND VGND VPWR VPWR sky130_fd_sc_hd__decap_3
XPHY_114 VGND VGND VPWR VPWR sky130_fd_sc_hd__decap_3
XFILLER_0_109_405 VPWR VGND VPWR VGND sky130_ef_sc_hd__decap_12
XPHY_136 VGND VGND VPWR VPWR sky130_fd_sc_hd__decap_3
XPHY_147 VGND VGND VPWR VPWR sky130_fd_sc_hd__decap_3
XPHY_158 VGND VGND VPWR VPWR sky130_fd_sc_hd__decap_3
XPHY_169 VGND VGND VPWR VPWR sky130_fd_sc_hd__decap_3
XFILLER_0_30_1331 VGND VGND VPWR VPWR sky130_fd_sc_hd__decap_6
XFILLER_0_109_449 VPWR VGND VPWR VGND sky130_ef_sc_hd__decap_12
XFILLER_0_164_1319 VPWR VGND VPWR VGND sky130_ef_sc_hd__decap_12
XFILLER_0_104_165 VGND VGND VPWR VPWR sky130_fd_sc_hd__decap_3
XANTENNA_input42_A psum_col0_in[17] VGND VGND VPWR VPWR sky130_fd_sc_hd__diode_2
XFILLER_0_101_1303 VGND VGND VPWR VPWR sky130_fd_sc_hd__decap_6
XFILLER_0_98_1225 VGND VGND VPWR VPWR sky130_fd_sc_hd__fill_1
XFILLER_0_27_27 VPWR VGND VPWR VGND sky130_ef_sc_hd__decap_12
XFILLER_0_118_29 VPWR VGND VPWR VGND sky130_ef_sc_hd__decap_12
XFILLER_0_138_1281 VGND VGND VPWR VPWR sky130_fd_sc_hd__fill_1
XFILLER_0_212_1309 VGND VGND VPWR VPWR sky130_fd_sc_hd__decap_6
XFILLER_0_187_647 VPWR VGND VPWR VGND sky130_ef_sc_hd__decap_12
XFILLER_0_43_15 VPWR VGND VPWR VGND sky130_ef_sc_hd__decap_12
XFILLER_0_210_1000 VGND VGND VPWR VPWR sky130_fd_sc_hd__decap_8
XFILLER_0_85_645 VGND VGND VPWR VPWR sky130_fd_sc_hd__fill_1
XPHY_5 VGND VGND VPWR VPWR sky130_fd_sc_hd__decap_3
XFILLER_0_35_1253 VGND VGND VPWR VPWR sky130_fd_sc_hd__fill_1
XFILLER_0_214_83 VGND VGND VPWR VPWR sky130_fd_sc_hd__fill_1
XPHY_670 VGND VGND VPWR VPWR sky130_fd_sc_hd__decap_3
XANTENNA_u_pe11_weight_in[7] net162 VGND VGND VPWR VPWR sky130_fd_sc_hd__diode_2
XFILLER_0_5_617 VPWR VGND VPWR VGND sky130_ef_sc_hd__decap_12
XPHY_681 VGND VGND VPWR VPWR sky130_fd_sc_hd__decap_3
XPHY_692 VGND VGND VPWR VPWR sky130_fd_sc_hd__decap_3
XFILLER_0_150_49 VGND VGND VPWR VPWR sky130_fd_sc_hd__fill_1
XFILLER_0_106_1203 VGND VGND VPWR VPWR sky130_fd_sc_hd__fill_1
XFILLER_0_159_47 VGND VGND VPWR VPWR sky130_fd_sc_hd__decap_3
XFILLER_0_42_1213 VPWR VGND VPWR VGND sky130_ef_sc_hd__decap_12
XFILLER_0_1_889 VGND VGND VPWR VPWR sky130_fd_sc_hd__decap_6
XFILLER_0_175_13 VPWR VGND VPWR VGND sky130_ef_sc_hd__decap_12
XFILLER_0_84_22 VGND VGND VPWR VPWR sky130_fd_sc_hd__decap_6
XFILLER_0_77_1309 VGND VGND VPWR VPWR sky130_fd_sc_hd__fill_1
XFILLER_0_225_559 VGND VGND VPWR VPWR sky130_fd_sc_hd__fill_1
XFILLER_0_212_209 VPWR VGND VPWR VGND sky130_ef_sc_hd__decap_12
XFILLER_0_221_721 VGND VGND VPWR VPWR sky130_fd_sc_hd__decap_6
XFILLER_0_152_1201 VPWR VGND VPWR VGND sky130_ef_sc_hd__decap_12
XFILLER_0_221_765 VPWR VGND VPWR VGND sky130_ef_sc_hd__decap_12
XFILLER_0_117_1343 VGND VGND VPWR VPWR sky130_fd_sc_hd__fill_1
XFILLER_0_193_617 VPWR VGND VPWR VGND sky130_ef_sc_hd__decap_12
XFILLER_0_220_253 VPWR VGND VPWR VGND sky130_ef_sc_hd__decap_12
XFILLER_0_14_1337 VGND VGND VPWR VPWR sky130_fd_sc_hd__fill_1
XFILLER_0_107_909 VPWR VGND VPWR VGND sky130_ef_sc_hd__decap_12
XFILLER_0_106_419 VGND VGND VPWR VPWR sky130_fd_sc_hd__fill_1
XFILLER_0_226_1040 VGND VGND VPWR VPWR sky130_fd_sc_hd__fill_2
Xinput90 psum_col1_in[31] VGND VGND VPWR VPWR net90 sky130_fd_sc_hd__clkbuf_2
XFILLER_0_226_1084 VGND VGND VPWR VPWR sky130_fd_sc_hd__decap_8
XFILLER_0_226_1062 VGND VGND VPWR VPWR sky130_fd_sc_hd__fill_2
XFILLER_0_3_193 VPWR VGND VPWR VGND sky130_ef_sc_hd__decap_12
XFILLER_0_200_1213 VPWR VGND VPWR VGND sky130_ef_sc_hd__decap_12
XFILLER_0_219_39 VPWR VGND VPWR VGND sky130_ef_sc_hd__decap_12
XFILLER_0_97_1291 VPWR VGND VPWR VGND sky130_ef_sc_hd__decap_12
XFILLER_0_224_581 VGND VGND VPWR VPWR sky130_fd_sc_hd__decap_6
XFILLER_0_58_1275 VGND VGND VPWR VPWR sky130_fd_sc_hd__decap_6
XFILLER_0_169_647 VGND VGND VPWR VPWR sky130_fd_sc_hd__decap_8
XFILLER_0_19_1237 VPWR VGND VPWR VGND sky130_ef_sc_hd__decap_12
XFILLER_0_184_617 VGND VGND VPWR VPWR sky130_fd_sc_hd__fill_1
XFILLER_0_67_645 VGND VGND VPWR VPWR sky130_fd_sc_hd__fill_1
XFILLER_0_109_279 VGND VGND VPWR VPWR sky130_fd_sc_hd__fill_1
XFILLER_0_168_1263 VPWR VGND VPWR VGND sky130_ef_sc_hd__decap_12
XFILLER_0_129_1225 VPWR VGND VPWR VGND sky130_ef_sc_hd__decap_12
XFILLER_0_65_1213 VPWR VGND VPWR VGND sky130_ef_sc_hd__decap_12
XFILLER_0_105_441 VGND VGND VPWR VPWR sky130_fd_sc_hd__decap_6
XFILLER_0_200_41 VGND VGND VPWR VPWR sky130_fd_sc_hd__decap_8
XFILLER_0_65_1279 VPWR VGND VPWR VGND sky130_ef_sc_hd__decap_12
XFILLER_0_105_485 VPWR VGND VPWR VGND sky130_ef_sc_hd__decap_12
XFILLER_0_175_1201 VPWR VGND VPWR VGND sky130_ef_sc_hd__decap_12
XFILLER_0_76_1331 VGND VGND VPWR VPWR sky130_fd_sc_hd__decap_6
XFILLER_0_145_27 VPWR VGND VPWR VGND sky130_ef_sc_hd__decap_12
XFILLER_0_175_1267 VPWR VGND VPWR VGND sky130_ef_sc_hd__decap_12
XFILLER_0_216_1253 VGND VGND VPWR VPWR sky130_fd_sc_hd__decap_6
XFILLER_0_72_1239 VPWR VGND VPWR VGND sky130_ef_sc_hd__decap_12
XFILLER_0_216_1297 VPWR VGND VPWR VGND sky130_ef_sc_hd__decap_12
XFILLER_0_212_1117 VPWR VGND VPWR VGND sky130_ef_sc_hd__decap_12
XFILLER_0_175_617 VPWR VGND VPWR VGND sky130_ef_sc_hd__decap_12
XFILLER_0_225_93 VPWR VGND VPWR VGND sky130_ef_sc_hd__decap_12
XFILLER_0_214_3 VPWR VGND VPWR VGND sky130_ef_sc_hd__decap_12
XFILLER_0_147_1303 VGND VGND VPWR VPWR sky130_fd_sc_hd__decap_6
XFILLER_0_112_1273 VPWR VGND VPWR VGND sky130_ef_sc_hd__decap_12
XFILLER_0_6_937 VPWR VGND VPWR VGND sky130_ef_sc_hd__decap_12
XFILLER_0_5_447 VGND VGND VPWR VPWR sky130_fd_sc_hd__fill_1
XANTENNA_u_pe01_psum_in[23] net81 VGND VGND VPWR VPWR sky130_fd_sc_hd__diode_2
XFILLER_0_182_1227 VPWR VGND VPWR VGND sky130_ef_sc_hd__decap_12
XFILLER_0_108_1309 VGND VGND VPWR VPWR sky130_fd_sc_hd__decap_6
XFILLER_0_83_1335 VGND VGND VPWR VPWR sky130_fd_sc_hd__fill_1
XFILLER_0_223_1213 VPWR VGND VPWR VGND sky130_ef_sc_hd__decap_12
XFILLER_0_112_923 VGND VGND VPWR VPWR sky130_fd_sc_hd__fill_1
XFILLER_0_44_1319 VPWR VGND VPWR VGND sky130_ef_sc_hd__decap_12
XFILLER_0_110_41 VPWR VGND VPWR VGND sky130_ef_sc_hd__decap_12
XFILLER_0_223_1257 VPWR VGND VPWR VGND sky130_ef_sc_hd__decap_12
XFILLER_0_1_653 VPWR VGND VPWR VGND sky130_ef_sc_hd__decap_12
XFILLER_0_110_85 VPWR VGND VPWR VGND sky130_ef_sc_hd__decap_12
XFILLER_0_0_163 VGND VGND VPWR VPWR sky130_fd_sc_hd__decap_4
XFILLER_0_226_813 VGND VGND VPWR VPWR sky130_fd_sc_hd__fill_2
XFILLER_0_1_697 VPWR VGND VPWR VGND sky130_ef_sc_hd__decap_12
XFILLER_0_0_185 VGND VGND VPWR VPWR sky130_fd_sc_hd__decap_8
XFILLER_0_193_1323 VPWR VGND VPWR VGND sky130_ef_sc_hd__decap_12
XFILLER_0_213_529 VPWR VGND VPWR VGND sky130_ef_sc_hd__decap_12
XFILLER_0_154_1307 VPWR VGND VPWR VGND sky130_ef_sc_hd__decap_12
XTAP_2309 VGND VPWR sky130_fd_sc_hd__tapvpwrvgnd_1
XFILLER_0_221_573 VPWR VGND VPWR VGND sky130_ef_sc_hd__decap_12
XFILLER_0_90_1339 VGND VGND VPWR VPWR sky130_fd_sc_hd__decap_4
XFILLER_0_166_617 VGND VGND VPWR VPWR sky130_fd_sc_hd__fill_1
XTAP_1608 VGND VPWR sky130_fd_sc_hd__tapvpwrvgnd_1
XTAP_1619 VGND VPWR sky130_fd_sc_hd__tapvpwrvgnd_1
XFILLER_0_49_645 VGND VGND VPWR VPWR sky130_fd_sc_hd__fill_1
XFILLER_0_7_1257 VGND VGND VPWR VPWR sky130_fd_sc_hd__decap_3
XFILLER_0_18_1281 VGND VGND VPWR VPWR sky130_fd_sc_hd__fill_1
XFILLER_0_88_1213 VPWR VGND VPWR VGND sky130_ef_sc_hd__decap_12
XFILLER_0_114_293 VPWR VGND VPWR VGND sky130_ef_sc_hd__decap_12
XFILLER_0_202_1319 VPWR VGND VPWR VGND sky130_ef_sc_hd__decap_12
XFILLER_0_198_1201 VPWR VGND VPWR VGND sky130_ef_sc_hd__decap_12
XFILLER_0_216_301 VGND VGND VPWR VPWR sky130_fd_sc_hd__decap_6
XANTENNA_input144_A w10[5] VGND VGND VPWR VPWR sky130_fd_sc_hd__diode_2
XFILLER_0_216_345 VPWR VGND VPWR VGND sky130_ef_sc_hd__decap_12
XFILLER_0_216_389 VPWR VGND VPWR VGND sky130_ef_sc_hd__decap_12
XTAP_2821 VGND VPWR sky130_fd_sc_hd__tapvpwrvgnd_1
XTAP_2810 VGND VPWR sky130_fd_sc_hd__tapvpwrvgnd_1
XTAP_2843 VGND VPWR sky130_fd_sc_hd__tapvpwrvgnd_1
XTAP_2832 VGND VPWR sky130_fd_sc_hd__tapvpwrvgnd_1
XTAP_2854 VGND VPWR sky130_fd_sc_hd__tapvpwrvgnd_1
XTAP_2865 VGND VPWR sky130_fd_sc_hd__tapvpwrvgnd_1
XTAP_2887 VGND VPWR sky130_fd_sc_hd__tapvpwrvgnd_1
XTAP_2876 VGND VPWR sky130_fd_sc_hd__tapvpwrvgnd_1
XTAP_2898 VGND VPWR sky130_fd_sc_hd__tapvpwrvgnd_1
XFILLER_0_157_617 VPWR VGND VPWR VGND sky130_ef_sc_hd__decap_12
XFILLER_0_32_1201 VPWR VGND VPWR VGND sky130_ef_sc_hd__decap_12
XFILLER_0_40_27 VGND VGND VPWR VPWR sky130_fd_sc_hd__fill_1
XFILLER_0_180_631 VPWR VGND VPWR VGND sky130_ef_sc_hd__decap_12
XFILLER_0_40_49 VGND VGND VPWR VPWR sky130_fd_sc_hd__fill_1
XFILLER_0_211_51 VGND VGND VPWR VPWR sky130_fd_sc_hd__decap_4
XFILLER_0_113_709 VPWR VGND VPWR VGND sky130_ef_sc_hd__decap_12
XFILLER_0_49_25 VPWR VGND VPWR VGND sky130_ef_sc_hd__decap_12
Xoutput209 net209 VGND VGND VPWR VPWR psum_col1_out[20] sky130_fd_sc_hd__clkbuf_4
XFILLER_0_105_293 VPWR VGND VPWR VGND sky130_ef_sc_hd__decap_12
XFILLER_0_219_161 VGND VGND VPWR VPWR sky130_fd_sc_hd__decap_6
XFILLER_0_4_27 VGND VGND VPWR VPWR sky130_fd_sc_hd__fill_1
XFILLER_0_156_15 VPWR VGND VPWR VGND sky130_ef_sc_hd__decap_12
XFILLER_0_218_1315 VGND VGND VPWR VPWR sky130_fd_sc_hd__fill_1
XFILLER_0_216_1061 VPWR VGND VPWR VGND sky130_ef_sc_hd__decap_12
XFILLER_0_114_1313 VGND VGND VPWR VPWR sky130_fd_sc_hd__decap_3
XFILLER_0_148_617 VGND VGND VPWR VPWR sky130_fd_sc_hd__fill_1
XFILLER_0_6_701 VPWR VGND VPWR VGND sky130_ef_sc_hd__decap_12
XFILLER_0_61_629 VPWR VGND VPWR VGND sky130_ef_sc_hd__decap_12
XFILLER_0_108_1117 VPWR VGND VPWR VGND sky130_ef_sc_hd__decap_12
XFILLER_0_48_1263 VPWR VGND VPWR VGND sky130_ef_sc_hd__decap_12
XFILLER_0_223_1021 VPWR VGND VPWR VGND sky130_ef_sc_hd__decap_12
XFILLER_0_223_1065 VPWR VGND VPWR VGND sky130_ef_sc_hd__decap_12
XFILLER_0_69_3 VPWR VGND VPWR VGND sky130_ef_sc_hd__decap_12
XFILLER_0_1_461 VPWR VGND VPWR VGND sky130_ef_sc_hd__decap_12
XFILLER_0_2_973 VGND VGND VPWR VPWR sky130_fd_sc_hd__decap_6
XFILLER_0_214_805 VGND VGND VPWR VPWR sky130_fd_sc_hd__decap_6
XFILLER_0_214_849 VPWR VGND VPWR VGND sky130_ef_sc_hd__decap_12
XFILLER_0_216_29 VPWR VGND VPWR VGND sky130_ef_sc_hd__decap_12
XFILLER_0_158_1251 VPWR VGND VPWR VGND sky130_ef_sc_hd__decap_12
XFILLER_0_119_1213 VPWR VGND VPWR VGND sky130_ef_sc_hd__decap_12
XFILLER_0_213_337 VPWR VGND VPWR VGND sky130_ef_sc_hd__decap_12
XFILLER_0_158_1295 VPWR VGND VPWR VGND sky130_ef_sc_hd__decap_12
XTAP_2117 VGND VPWR sky130_fd_sc_hd__tapvpwrvgnd_1
XFILLER_0_55_1201 VPWR VGND VPWR VGND sky130_ef_sc_hd__decap_12
XTAP_2106 VGND VPWR sky130_fd_sc_hd__tapvpwrvgnd_1
XFILLER_0_119_1279 VPWR VGND VPWR VGND sky130_ef_sc_hd__decap_12
XTAP_2139 VGND VPWR sky130_fd_sc_hd__tapvpwrvgnd_1
XFILLER_0_94_1283 VPWR VGND VPWR VGND sky130_ef_sc_hd__decap_12
XTAP_2128 VGND VPWR sky130_fd_sc_hd__tapvpwrvgnd_1
XTAP_1405 VGND VPWR sky130_fd_sc_hd__tapvpwrvgnd_1
XFILLER_0_222_893 VPWR VGND VPWR VGND sky130_ef_sc_hd__decap_12
XFILLER_0_139_617 VPWR VGND VPWR VGND sky130_ef_sc_hd__decap_12
XTAP_1416 VGND VPWR sky130_fd_sc_hd__tapvpwrvgnd_1
XTAP_1427 VGND VPWR sky130_fd_sc_hd__tapvpwrvgnd_1
XTAP_1438 VGND VPWR sky130_fd_sc_hd__tapvpwrvgnd_1
XFILLER_0_7_1021 VPWR VGND VPWR VGND sky130_ef_sc_hd__decap_12
XFILLER_0_55_1267 VPWR VGND VPWR VGND sky130_ef_sc_hd__decap_12
XFILLER_0_7_1065 VPWR VGND VPWR VGND sky130_ef_sc_hd__decap_12
XTAP_1449 VGND VPWR sky130_fd_sc_hd__tapvpwrvgnd_1
XFILLER_0_107_503 VGND VGND VPWR VPWR sky130_fd_sc_hd__fill_1
XFILLER_0_162_631 VPWR VGND VPWR VGND sky130_ef_sc_hd__decap_12
XFILLER_0_165_1255 VPWR VGND VPWR VGND sky130_ef_sc_hd__decap_12
XFILLER_0_27_1303 VGND VGND VPWR VPWR sky130_fd_sc_hd__decap_6
XFILLER_0_126_1239 VPWR VGND VPWR VGND sky130_ef_sc_hd__decap_12
XFILLER_0_206_1263 VPWR VGND VPWR VGND sky130_ef_sc_hd__decap_12
XFILLER_0_62_1227 VPWR VGND VPWR VGND sky130_ef_sc_hd__decap_12
XFILLER_0_19_39 VGND VGND VPWR VPWR sky130_fd_sc_hd__decap_8
XFILLER_0_217_665 VGND VGND VPWR VPWR sky130_fd_sc_hd__decap_6
XFILLER_0_102_1283 VPWR VGND VPWR VGND sky130_ef_sc_hd__decap_12
XFILLER_0_216_153 VPWR VGND VPWR VGND sky130_ef_sc_hd__decap_12
XFILLER_0_126_29 VPWR VGND VPWR VGND sky130_ef_sc_hd__decap_12
XFILLER_0_216_197 VPWR VGND VPWR VGND sky130_ef_sc_hd__decap_12
XFILLER_0_137_1335 VGND VGND VPWR VPWR sky130_fd_sc_hd__fill_1
XFILLER_0_213_1201 VPWR VGND VPWR VGND sky130_ef_sc_hd__decap_12
XFILLER_0_34_1307 VPWR VGND VPWR VGND sky130_ef_sc_hd__decap_12
XFILLER_0_73_1323 VPWR VGND VPWR VGND sky130_ef_sc_hd__decap_12
XFILLER_0_213_1245 VPWR VGND VPWR VGND sky130_ef_sc_hd__decap_12
XTAP_2651 VGND VPWR sky130_fd_sc_hd__tapvpwrvgnd_1
XTAP_2662 VGND VPWR sky130_fd_sc_hd__tapvpwrvgnd_1
XTAP_2640 VGND VPWR sky130_fd_sc_hd__tapvpwrvgnd_1
XANTENNA_output209_A net209 VGND VGND VPWR VPWR sky130_fd_sc_hd__diode_2
XTAP_2684 VGND VPWR sky130_fd_sc_hd__tapvpwrvgnd_1
XTAP_2695 VGND VPWR sky130_fd_sc_hd__tapvpwrvgnd_1
XTAP_2673 VGND VPWR sky130_fd_sc_hd__tapvpwrvgnd_1
XTAP_1950 VGND VPWR sky130_fd_sc_hd__tapvpwrvgnd_1
XFILLER_0_51_15 VPWR VGND VPWR VGND sky130_ef_sc_hd__decap_12
XTAP_1961 VGND VPWR sky130_fd_sc_hd__tapvpwrvgnd_1
XFILLER_0_213_1289 VPWR VGND VPWR VGND sky130_ef_sc_hd__decap_12
XTAP_1972 VGND VPWR sky130_fd_sc_hd__tapvpwrvgnd_1
XTAP_1994 VGND VPWR sky130_fd_sc_hd__tapvpwrvgnd_1
XTAP_1983 VGND VPWR sky130_fd_sc_hd__tapvpwrvgnd_1
XFILLER_0_129_6 VGND VGND VPWR VPWR sky130_fd_sc_hd__fill_2
XFILLER_0_183_1311 VPWR VGND VPWR VGND sky130_ef_sc_hd__decap_12
XFILLER_0_222_83 VGND VGND VPWR VPWR sky130_fd_sc_hd__fill_1
XFILLER_0_43_629 VPWR VGND VPWR VGND sky130_ef_sc_hd__decap_12
XFILLER_0_113_517 VPWR VGND VPWR VGND sky130_ef_sc_hd__decap_12
XFILLER_0_224_1341 VGND VGND VPWR VPWR sky130_fd_sc_hd__decap_3
XFILLER_0_144_1339 VGND VGND VPWR VPWR sky130_fd_sc_hd__decap_4
XFILLER_0_220_1205 VPWR VGND VPWR VGND sky130_ef_sc_hd__decap_12
XFILLER_0_167_47 VGND VGND VPWR VPWR sky130_fd_sc_hd__fill_1
XFILLER_0_208_643 VPWR VGND VPWR VGND sky130_ef_sc_hd__decap_12
XFILLER_0_78_1201 VPWR VGND VPWR VGND sky130_ef_sc_hd__decap_12
XFILLER_0_190_1337 VGND VGND VPWR VPWR sky130_fd_sc_hd__fill_1
XFILLER_0_222_189 VGND VGND VPWR VPWR sky130_fd_sc_hd__decap_6
XFILLER_0_114_1121 VPWR VGND VPWR VGND sky130_ef_sc_hd__decap_12
XFILLER_0_4_1205 VPWR VGND VPWR VGND sky130_ef_sc_hd__decap_12
XPHY_1109 VGND VGND VPWR VPWR sky130_fd_sc_hd__decap_3
XFILLER_0_110_1029 VGND VGND VPWR VPWR sky130_fd_sc_hd__decap_6
XFILLER_0_144_631 VPWR VGND VPWR VGND sky130_ef_sc_hd__decap_12
XFILLER_0_6_531 VGND VGND VPWR VPWR sky130_fd_sc_hd__fill_1
XFILLER_0_104_517 VPWR VGND VPWR VGND sky130_ef_sc_hd__decap_12
XFILLER_0_85_1249 VGND VGND VPWR VPWR sky130_fd_sc_hd__decap_4
XFILLER_0_2_781 VPWR VGND VPWR VGND sky130_ef_sc_hd__decap_12
XFILLER_0_195_1237 VPWR VGND VPWR VGND sky130_ef_sc_hd__decap_12
XFILLER_0_226_440 VGND VGND VPWR VPWR sky130_fd_sc_hd__fill_1
XFILLER_0_5_81 VPWR VGND VPWR VGND sky130_ef_sc_hd__decap_12
XFILLER_0_214_613 VPWR VGND VPWR VGND sky130_ef_sc_hd__decap_12
XFILLER_0_214_657 VPWR VGND VPWR VGND sky130_ef_sc_hd__decap_12
XFILLER_0_213_167 VGND VGND VPWR VPWR sky130_fd_sc_hd__fill_1
XFILLER_0_210_841 VPWR VGND VPWR VGND sky130_ef_sc_hd__decap_12
XTAP_1246 VGND VPWR sky130_fd_sc_hd__tapvpwrvgnd_1
XTAP_1235 VGND VPWR sky130_fd_sc_hd__tapvpwrvgnd_1
XTAP_1224 VGND VPWR sky130_fd_sc_hd__tapvpwrvgnd_1
XTAP_1257 VGND VPWR sky130_fd_sc_hd__tapvpwrvgnd_1
XANTENNA_input107_A w00[15] VGND VGND VPWR VPWR sky130_fd_sc_hd__diode_2
XTAP_1279 VGND VPWR sky130_fd_sc_hd__tapvpwrvgnd_1
XTAP_1268 VGND VPWR sky130_fd_sc_hd__tapvpwrvgnd_1
XFILLER_0_108_867 VGND VGND VPWR VPWR sky130_fd_sc_hd__fill_1
XFILLER_0_25_629 VPWR VGND VPWR VGND sky130_ef_sc_hd__decap_12
XANTENNA_input72_A psum_col1_in[15] VGND VGND VPWR VPWR sky130_fd_sc_hd__diode_2
XFILLER_0_104_1301 VPWR VGND VPWR VGND sky130_ef_sc_hd__decap_12
XFILLER_0_46_15 VPWR VGND VPWR VGND sky130_ef_sc_hd__decap_12
XFILLER_0_217_473 VPWR VGND VPWR VGND sky130_ef_sc_hd__decap_12
XFILLER_0_137_39 VGND VGND VPWR VPWR sky130_fd_sc_hd__decap_8
XFILLER_0_38_1251 VPWR VGND VPWR VGND sky130_ef_sc_hd__decap_12
XFILLER_0_153_27 VPWR VGND VPWR VGND sky130_ef_sc_hd__decap_12
XTAP_2470 VGND VPWR sky130_fd_sc_hd__tapvpwrvgnd_1
XTAP_2481 VGND VPWR sky130_fd_sc_hd__tapvpwrvgnd_1
XFILLER_0_150_1343 VGND VGND VPWR VPWR sky130_fd_sc_hd__fill_1
XFILLER_0_38_1295 VPWR VGND VPWR VGND sky130_ef_sc_hd__decap_12
XTAP_2492 VGND VPWR sky130_fd_sc_hd__tapvpwrvgnd_1
XTAP_1791 VGND VPWR sky130_fd_sc_hd__tapvpwrvgnd_1
XTAP_1780 VGND VPWR sky130_fd_sc_hd__tapvpwrvgnd_1
XFILLER_0_127_3 VPWR VGND VPWR VGND sky130_ef_sc_hd__decap_12
XFILLER_0_126_631 VPWR VGND VPWR VGND sky130_ef_sc_hd__decap_12
XFILLER_0_109_1201 VPWR VGND VPWR VGND sky130_ef_sc_hd__decap_12
XFILLER_0_114_837 VGND VGND VPWR VPWR sky130_fd_sc_hd__decap_3
XFILLER_0_178_13 VPWR VGND VPWR VGND sky130_ef_sc_hd__decap_12
XFILLER_0_148_1283 VPWR VGND VPWR VGND sky130_ef_sc_hd__decap_12
XFILLER_0_109_1245 VPWR VGND VPWR VGND sky130_ef_sc_hd__decap_12
XFILLER_0_141_645 VGND VGND VPWR VPWR sky130_fd_sc_hd__fill_1
XFILLER_0_87_22 VPWR VGND VPWR VGND sky130_ef_sc_hd__decap_12
XFILLER_0_109_1289 VPWR VGND VPWR VGND sky130_ef_sc_hd__decap_12
XFILLER_0_45_1255 VPWR VGND VPWR VGND sky130_ef_sc_hd__decap_12
XFILLER_0_220_1035 VGND VGND VPWR VPWR sky130_fd_sc_hd__fill_1
XFILLER_0_194_1281 VGND VGND VPWR VPWR sky130_fd_sc_hd__fill_1
XFILLER_0_116_1227 VPWR VGND VPWR VGND sky130_ef_sc_hd__decap_12
XFILLER_0_91_1253 VGND VGND VPWR VPWR sky130_fd_sc_hd__fill_1
XPHY_307 VGND VGND VPWR VPWR sky130_fd_sc_hd__decap_3
XFILLER_0_109_609 VGND VGND VPWR VPWR sky130_fd_sc_hd__decap_6
XPHY_329 VGND VGND VPWR VPWR sky130_fd_sc_hd__decap_3
XPHY_318 VGND VGND VPWR VPWR sky130_fd_sc_hd__decap_3
XFILLER_0_4_1035 VGND VGND VPWR VPWR sky130_fd_sc_hd__fill_1
XFILLER_0_162_1225 VGND VGND VPWR VPWR sky130_fd_sc_hd__fill_1
XFILLER_0_127_1323 VPWR VGND VPWR VGND sky130_ef_sc_hd__decap_12
XFILLER_0_63_1311 VPWR VGND VPWR VGND sky130_ef_sc_hd__decap_12
XFILLER_0_30_643 VPWR VGND VPWR VGND sky130_ef_sc_hd__decap_12
XFILLER_0_203_1255 VPWR VGND VPWR VGND sky130_ef_sc_hd__decap_12
XFILLER_0_219_727 VGND VGND VPWR VPWR sky130_fd_sc_hd__fill_1
XFILLER_0_24_1339 VGND VGND VPWR VPWR sky130_fd_sc_hd__decap_4
XFILLER_0_215_933 VPWR VGND VPWR VGND sky130_ef_sc_hd__decap_12
XFILLER_0_226_292 VPWR VGND VPWR VGND sky130_ef_sc_hd__decap_12
XFILLER_0_226_281 VGND VGND VPWR VPWR sky130_fd_sc_hd__decap_6
XFILLER_0_226_270 VGND VGND VPWR VPWR sky130_fd_sc_hd__decap_8
XFILLER_0_214_421 VPWR VGND VPWR VGND sky130_ef_sc_hd__decap_12
XFILLER_0_215_977 VPWR VGND VPWR VGND sky130_ef_sc_hd__decap_12
XFILLER_0_202_605 VPWR VGND VPWR VGND sky130_ef_sc_hd__decap_12
XFILLER_0_199_645 VGND VGND VPWR VPWR sky130_fd_sc_hd__fill_1
XFILLER_0_16_29 VPWR VGND VPWR VGND sky130_ef_sc_hd__decap_12
XFILLER_0_70_1337 VGND VGND VPWR VPWR sky130_fd_sc_hd__fill_1
XPHY_852 VGND VGND VPWR VPWR sky130_fd_sc_hd__decap_3
XPHY_841 VGND VGND VPWR VPWR sky130_fd_sc_hd__decap_3
XPHY_863 VGND VGND VPWR VPWR sky130_fd_sc_hd__decap_3
XPHY_830 VGND VGND VPWR VPWR sky130_fd_sc_hd__decap_3
XPHY_874 VGND VGND VPWR VPWR sky130_fd_sc_hd__decap_3
XPHY_885 VGND VGND VPWR VPWR sky130_fd_sc_hd__decap_3
XPHY_896 VGND VGND VPWR VPWR sky130_fd_sc_hd__decap_3
XFILLER_0_4_309 VPWR VGND VPWR VGND sky130_ef_sc_hd__decap_12
XFILLER_0_123_645 VGND VGND VPWR VPWR sky130_fd_sc_hd__fill_1
XFILLER_0_141_1309 VGND VGND VPWR VPWR sky130_fd_sc_hd__fill_1
XFILLER_0_104_881 VPWR VGND VPWR VGND sky130_ef_sc_hd__decap_12
XFILLER_0_0_515 VPWR VGND VPWR VGND sky130_ef_sc_hd__decap_12
XFILLER_0_0_559 VGND VGND VPWR VPWR sky130_fd_sc_hd__fill_1
XFILLER_0_148_27 VGND VGND VPWR VPWR sky130_fd_sc_hd__fill_1
XFILLER_0_57_47 VGND VGND VPWR VPWR sky130_fd_sc_hd__fill_1
XFILLER_0_148_49 VGND VGND VPWR VPWR sky130_fd_sc_hd__fill_1
XFILLER_0_218_793 VPWR VGND VPWR VGND sky130_ef_sc_hd__decap_12
XFILLER_0_217_281 VPWR VGND VPWR VGND sky130_ef_sc_hd__decap_12
XFILLER_0_139_1249 VGND VGND VPWR VPWR sky130_fd_sc_hd__decap_4
XFILLER_0_73_46 VGND VGND VPWR VPWR sky130_fd_sc_hd__decap_4
XFILLER_0_75_1237 VPWR VGND VPWR VGND sky130_ef_sc_hd__decap_12
XFILLER_0_220_413 VGND VGND VPWR VPWR sky130_fd_sc_hd__decap_6
XFILLER_0_88_643 VPWR VGND VPWR VGND sky130_ef_sc_hd__decap_12
XFILLER_0_220_457 VPWR VGND VPWR VGND sky130_ef_sc_hd__decap_12
XFILLER_0_111_1113 VGND VGND VPWR VPWR sky130_fd_sc_hd__decap_6
XFILLER_0_185_1225 VPWR VGND VPWR VGND sky130_ef_sc_hd__decap_12
XFILLER_0_111_1157 VPWR VGND VPWR VGND sky130_ef_sc_hd__decap_12
XFILLER_0_7_125 VPWR VGND VPWR VGND sky130_ef_sc_hd__decap_12
XFILLER_0_114_601 VPWR VGND VPWR VGND sky130_ef_sc_hd__decap_12
XFILLER_0_7_169 VPWR VGND VPWR VGND sky130_ef_sc_hd__decap_12
XFILLER_0_98_10 VPWR VGND VPWR VGND sky130_ef_sc_hd__decap_12
XFILLER_0_189_45 VGND VGND VPWR VPWR sky130_fd_sc_hd__decap_3
XFILLER_0_114_645 VPWR VGND VPWR VGND sky130_ef_sc_hd__decap_12
XFILLER_0_113_111 VGND VGND VPWR VPWR sky130_fd_sc_hd__fill_1
XFILLER_0_226_1277 VGND VGND VPWR VPWR sky130_fd_sc_hd__fill_1
XFILLER_0_226_1255 VGND VGND VPWR VPWR sky130_fd_sc_hd__decap_3
XFILLER_0_12_643 VPWR VGND VPWR VGND sky130_ef_sc_hd__decap_12
XFILLER_0_161_1291 VPWR VGND VPWR VGND sky130_ef_sc_hd__decap_12
XFILLER_0_51_3 VPWR VGND VPWR VGND sky130_ef_sc_hd__decap_12
Xinput109 w00[2] VGND VGND VPWR VPWR net109 sky130_fd_sc_hd__buf_1
XFILLER_0_122_1275 VGND VGND VPWR VPWR sky130_fd_sc_hd__decap_6
XFILLER_0_212_925 VPWR VGND VPWR VGND sky130_ef_sc_hd__decap_12
XFILLER_0_223_273 VGND VGND VPWR VPWR sky130_fd_sc_hd__decap_6
XFILLER_0_224_29 VPWR VGND VPWR VGND sky130_ef_sc_hd__decap_12
XPHY_115 VGND VGND VPWR VPWR sky130_fd_sc_hd__decap_3
XPHY_104 VGND VGND VPWR VPWR sky130_fd_sc_hd__decap_3
XPHY_148 VGND VGND VPWR VPWR sky130_fd_sc_hd__decap_3
XPHY_137 VGND VGND VPWR VPWR sky130_fd_sc_hd__decap_3
XPHY_126 VGND VGND VPWR VPWR sky130_fd_sc_hd__decap_3
XFILLER_0_109_417 VPWR VGND VPWR VGND sky130_ef_sc_hd__decap_12
XFILLER_0_30_1343 VGND VGND VPWR VPWR sky130_fd_sc_hd__fill_1
XPHY_159 VGND VGND VPWR VPWR sky130_fd_sc_hd__decap_3
XFILLER_0_140_1331 VGND VGND VPWR VPWR sky130_fd_sc_hd__decap_6
XFILLER_0_28_1283 VPWR VGND VPWR VGND sky130_ef_sc_hd__decap_12
XANTENNA_input35_A psum_col0_in[10] VGND VGND VPWR VPWR sky130_fd_sc_hd__diode_2
XFILLER_0_27_39 VGND VGND VPWR VPWR sky130_fd_sc_hd__decap_8
XFILLER_0_215_741 VPWR VGND VPWR VGND sky130_ef_sc_hd__decap_12
XFILLER_0_215_785 VPWR VGND VPWR VGND sky130_ef_sc_hd__decap_12
XFILLER_0_214_251 VGND VGND VPWR VPWR sky130_fd_sc_hd__fill_1
XFILLER_0_43_27 VPWR VGND VPWR VGND sky130_ef_sc_hd__decap_12
XFILLER_0_134_29 VPWR VGND VPWR VGND sky130_ef_sc_hd__decap_12
XPHY_6 VGND VGND VPWR VPWR sky130_fd_sc_hd__decap_3
XFILLER_0_74_1281 VGND VGND VPWR VPWR sky130_fd_sc_hd__fill_1
XFILLER_0_210_1045 VPWR VGND VPWR VGND sky130_ef_sc_hd__decap_12
XPHY_660 VGND VGND VPWR VPWR sky130_fd_sc_hd__decap_3
XPHY_671 VGND VGND VPWR VPWR sky130_fd_sc_hd__decap_3
XFILLER_0_109_951 VGND VGND VPWR VPWR sky130_fd_sc_hd__fill_1
XANTENNA_u_pe11_weight_in[6] net161 VGND VGND VPWR VPWR sky130_fd_sc_hd__diode_2
XPHY_682 VGND VGND VPWR VPWR sky130_fd_sc_hd__decap_3
XFILLER_0_5_629 VPWR VGND VPWR VGND sky130_ef_sc_hd__decap_12
XPHY_693 VGND VGND VPWR VPWR sky130_fd_sc_hd__decap_3
XFILLER_0_4_139 VGND VGND VPWR VPWR sky130_fd_sc_hd__fill_1
XFILLER_0_0_1241 VPWR VGND VPWR VGND sky130_ef_sc_hd__decap_12
XFILLER_0_0_1285 VGND VGND VPWR VPWR sky130_fd_sc_hd__decap_3
XFILLER_0_159_15 VPWR VGND VPWR VGND sky130_ef_sc_hd__decap_12
XFILLER_0_145_1253 VGND VGND VPWR VPWR sky130_fd_sc_hd__fill_1
XFILLER_0_111_615 VGND VGND VPWR VPWR sky130_fd_sc_hd__fill_1
XFILLER_0_106_1259 VGND VGND VPWR VPWR sky130_fd_sc_hd__fill_1
XFILLER_0_42_1225 VGND VGND VPWR VPWR sky130_fd_sc_hd__fill_1
XFILLER_0_194_3 VPWR VGND VPWR VGND sky130_ef_sc_hd__decap_12
XFILLER_0_225_505 VPWR VGND VPWR VGND sky130_ef_sc_hd__decap_12
XFILLER_0_175_25 VPWR VGND VPWR VGND sky130_ef_sc_hd__decap_12
XFILLER_0_108_41 VPWR VGND VPWR VGND sky130_ef_sc_hd__decap_12
XFILLER_0_117_1311 VPWR VGND VPWR VGND sky130_ef_sc_hd__decap_12
XFILLER_0_108_85 VPWR VGND VPWR VGND sky130_ef_sc_hd__decap_12
XFILLER_0_220_221 VPWR VGND VPWR VGND sky130_ef_sc_hd__decap_12
XFILLER_0_152_1213 VPWR VGND VPWR VGND sky130_ef_sc_hd__decap_12
XFILLER_0_221_777 VGND VGND VPWR VPWR sky130_fd_sc_hd__decap_6
XFILLER_0_220_265 VPWR VGND VPWR VGND sky130_ef_sc_hd__decap_12
XFILLER_0_187_1309 VGND VGND VPWR VPWR sky130_fd_sc_hd__fill_1
XFILLER_0_193_629 VPWR VGND VPWR VGND sky130_ef_sc_hd__decap_12
XFILLER_0_91_605 VPWR VGND VPWR VGND sky130_ef_sc_hd__decap_12
XFILLER_0_99_3 VPWR VGND VPWR VGND sky130_ef_sc_hd__decap_12
XFILLER_0_226_1030 VGND VGND VPWR VPWR sky130_fd_sc_hd__decap_6
Xinput80 psum_col1_in[22] VGND VGND VPWR VPWR net80 sky130_fd_sc_hd__dlymetal6s2s_1
Xinput91 psum_col1_in[3] VGND VGND VPWR VPWR net91 sky130_fd_sc_hd__buf_1
XFILLER_0_3_161 VGND VGND VPWR VPWR sky130_fd_sc_hd__decap_6
XFILLER_0_124_1337 VGND VGND VPWR VPWR sky130_fd_sc_hd__fill_1
XFILLER_0_7_9 VGND VGND VPWR VPWR sky130_fd_sc_hd__fill_2
XFILLER_0_21_1309 VGND VGND VPWR VPWR sky130_fd_sc_hd__fill_1
XFILLER_0_200_1225 VGND VGND VPWR VPWR sky130_fd_sc_hd__fill_1
XFILLER_0_110_681 VPWR VGND VPWR VGND sky130_ef_sc_hd__decap_12
XFILLER_0_212_755 VGND VGND VPWR VPWR sky130_fd_sc_hd__fill_1
XFILLER_0_19_1249 VGND VGND VPWR VPWR sky130_fd_sc_hd__decap_4
XFILLER_0_211_1343 VGND VGND VPWR VPWR sky130_fd_sc_hd__fill_1
XFILLER_0_82_605 VPWR VGND VPWR VGND sky130_ef_sc_hd__decap_12
XFILLER_0_109_225 VPWR VGND VPWR VGND sky130_ef_sc_hd__decap_12
XFILLER_0_168_1275 VGND VGND VPWR VPWR sky130_fd_sc_hd__decap_6
XFILLER_0_129_1237 VPWR VGND VPWR VGND sky130_ef_sc_hd__decap_12
XFILLER_0_65_1225 VPWR VGND VPWR VGND sky130_ef_sc_hd__decap_12
XFILLER_0_105_497 VGND VGND VPWR VPWR sky130_fd_sc_hd__decap_6
XFILLER_0_105_1281 VGND VGND VPWR VPWR sky130_fd_sc_hd__decap_6
XFILLER_0_38_49 VGND VGND VPWR VPWR sky130_fd_sc_hd__fill_1
XFILLER_0_175_1213 VPWR VGND VPWR VGND sky130_ef_sc_hd__decap_12
XFILLER_0_41_1291 VPWR VGND VPWR VGND sky130_ef_sc_hd__decap_12
XFILLER_0_175_1279 VPWR VGND VPWR VGND sky130_ef_sc_hd__decap_12
XFILLER_0_54_15 VPWR VGND VPWR VGND sky130_ef_sc_hd__decap_12
XFILLER_0_76_1343 VGND VGND VPWR VPWR sky130_fd_sc_hd__fill_1
XFILLER_0_145_39 VGND VGND VPWR VPWR sky130_fd_sc_hd__decap_8
XFILLER_0_212_1129 VPWR VGND VPWR VGND sky130_ef_sc_hd__decap_12
XFILLER_0_175_629 VPWR VGND VPWR VGND sky130_ef_sc_hd__decap_12
XFILLER_0_112_1241 VPWR VGND VPWR VGND sky130_ef_sc_hd__decap_12
XFILLER_0_73_605 VPWR VGND VPWR VGND sky130_ef_sc_hd__decap_12
XFILLER_0_186_1331 VGND VGND VPWR VPWR sky130_fd_sc_hd__decap_6
XFILLER_0_112_1285 VPWR VGND VPWR VGND sky130_ef_sc_hd__decap_12
XFILLER_0_6_905 VPWR VGND VPWR VGND sky130_ef_sc_hd__decap_12
XPHY_490 VGND VGND VPWR VPWR sky130_fd_sc_hd__decap_3
XFILLER_0_6_949 VPWR VGND VPWR VGND sky130_ef_sc_hd__decap_12
XANTENNA_u_pe01_psum_in[22] net80 VGND VGND VPWR VPWR sky130_fd_sc_hd__diode_2
XFILLER_0_182_1239 VPWR VGND VPWR VGND sky130_ef_sc_hd__decap_12
XFILLER_0_207_3 VPWR VGND VPWR VGND sky130_ef_sc_hd__decap_12
XFILLER_0_0_1071 VGND VGND VPWR VPWR sky130_fd_sc_hd__decap_8
XFILLER_0_83_1303 VGND VGND VPWR VPWR sky130_fd_sc_hd__decap_6
XFILLER_0_223_1225 VGND VGND VPWR VPWR sky130_fd_sc_hd__decap_6
XFILLER_0_0_1093 VGND VGND VPWR VPWR sky130_fd_sc_hd__decap_8
XFILLER_0_110_53 VPWR VGND VPWR VGND sky130_ef_sc_hd__decap_12
XFILLER_0_223_1269 VPWR VGND VPWR VGND sky130_ef_sc_hd__decap_12
XFILLER_0_112_979 VGND VGND VPWR VPWR sky130_fd_sc_hd__fill_1
XFILLER_0_1_665 VGND VGND VPWR VPWR sky130_fd_sc_hd__decap_6
XFILLER_0_0_131 VGND VGND VPWR VPWR sky130_fd_sc_hd__decap_8
XFILLER_0_110_97 VPWR VGND VPWR VGND sky130_ef_sc_hd__decap_12
XFILLER_0_0_197 VGND VGND VPWR VPWR sky130_fd_sc_hd__decap_4
XFILLER_0_225_335 VGND VGND VPWR VPWR sky130_fd_sc_hd__fill_1
XFILLER_0_20_1331 VGND VGND VPWR VPWR sky130_fd_sc_hd__decap_6
XFILLER_0_217_1007 VGND VGND VPWR VPWR sky130_fd_sc_hd__fill_1
XFILLER_0_193_1335 VGND VGND VPWR VPWR sky130_fd_sc_hd__decap_8
XFILLER_0_226_869 VPWR VGND VPWR VGND sky130_ef_sc_hd__decap_12
XFILLER_0_154_1319 VPWR VGND VPWR VGND sky130_ef_sc_hd__decap_12
XFILLER_0_221_541 VPWR VGND VPWR VGND sky130_ef_sc_hd__decap_12
XFILLER_0_206_593 VPWR VGND VPWR VGND sky130_ef_sc_hd__decap_12
XFILLER_0_90_1307 VPWR VGND VPWR VGND sky130_ef_sc_hd__decap_12
XTAP_1609 VGND VPWR sky130_fd_sc_hd__tapvpwrvgnd_1
XFILLER_0_221_585 VPWR VGND VPWR VGND sky130_ef_sc_hd__decap_12
XFILLER_0_64_605 VPWR VGND VPWR VGND sky130_ef_sc_hd__decap_12
XFILLER_0_88_1225 VGND VGND VPWR VPWR sky130_fd_sc_hd__fill_1
XFILLER_0_107_729 VPWR VGND VPWR VGND sky130_ef_sc_hd__decap_12
XFILLER_0_128_1281 VGND VGND VPWR VPWR sky130_fd_sc_hd__fill_1
XFILLER_0_198_1213 VPWR VGND VPWR VGND sky130_ef_sc_hd__decap_12
XFILLER_0_25_1253 VGND VGND VPWR VPWR sky130_fd_sc_hd__fill_1
XFILLER_0_99_1343 VGND VGND VPWR VPWR sky130_fd_sc_hd__fill_1
XFILLER_0_216_357 VGND VGND VPWR VPWR sky130_fd_sc_hd__decap_6
XANTENNA_input137_A w10[13] VGND VGND VPWR VPWR sky130_fd_sc_hd__diode_2
XTAP_2800 VGND VPWR sky130_fd_sc_hd__tapvpwrvgnd_1
XTAP_2811 VGND VPWR sky130_fd_sc_hd__tapvpwrvgnd_1
XTAP_2822 VGND VPWR sky130_fd_sc_hd__tapvpwrvgnd_1
XTAP_2844 VGND VPWR sky130_fd_sc_hd__tapvpwrvgnd_1
XTAP_2833 VGND VPWR sky130_fd_sc_hd__tapvpwrvgnd_1
XTAP_2855 VGND VPWR sky130_fd_sc_hd__tapvpwrvgnd_1
XFILLER_0_24_29 VPWR VGND VPWR VGND sky130_ef_sc_hd__decap_12
XTAP_2866 VGND VPWR sky130_fd_sc_hd__tapvpwrvgnd_1
XTAP_2888 VGND VPWR sky130_fd_sc_hd__tapvpwrvgnd_1
XTAP_2877 VGND VPWR sky130_fd_sc_hd__tapvpwrvgnd_1
XFILLER_0_157_629 VPWR VGND VPWR VGND sky130_ef_sc_hd__decap_12
XFILLER_0_32_1213 VPWR VGND VPWR VGND sky130_ef_sc_hd__decap_12
XTAP_2899 VGND VPWR sky130_fd_sc_hd__tapvpwrvgnd_1
XFILLER_0_55_605 VPWR VGND VPWR VGND sky130_ef_sc_hd__decap_12
XFILLER_0_70_619 VPWR VGND VPWR VGND sky130_ef_sc_hd__decap_12
XFILLER_0_67_1309 VGND VGND VPWR VPWR sky130_fd_sc_hd__fill_1
XFILLER_0_180_643 VPWR VGND VPWR VGND sky130_ef_sc_hd__decap_12
XFILLER_0_105_261 VPWR VGND VPWR VGND sky130_ef_sc_hd__decap_12
XFILLER_0_112_209 VPWR VGND VPWR VGND sky130_ef_sc_hd__decap_12
XFILLER_0_142_1201 VPWR VGND VPWR VGND sky130_ef_sc_hd__decap_12
XFILLER_0_49_37 VGND VGND VPWR VPWR sky130_fd_sc_hd__decap_8
XFILLER_0_156_27 VGND VGND VPWR VPWR sky130_fd_sc_hd__fill_1
XFILLER_0_65_47 VGND VGND VPWR VPWR sky130_fd_sc_hd__decap_3
XFILLER_0_156_49 VGND VGND VPWR VPWR sky130_fd_sc_hd__fill_1
XFILLER_0_223_839 VGND VGND VPWR VPWR sky130_fd_sc_hd__fill_1
XFILLER_0_172_15 VPWR VGND VPWR VGND sky130_ef_sc_hd__decap_12
XFILLER_0_216_1073 VPWR VGND VPWR VGND sky130_ef_sc_hd__decap_12
XFILLER_0_46_605 VPWR VGND VPWR VGND sky130_ef_sc_hd__decap_12
XFILLER_0_112_1093 VPWR VGND VPWR VGND sky130_ef_sc_hd__decap_12
XFILLER_0_6_713 VPWR VGND VPWR VGND sky130_ef_sc_hd__decap_12
XFILLER_0_5_223 VGND VGND VPWR VPWR sky130_fd_sc_hd__fill_1
XFILLER_0_6_757 VPWR VGND VPWR VGND sky130_ef_sc_hd__decap_12
XFILLER_0_108_1129 VPWR VGND VPWR VGND sky130_ef_sc_hd__decap_12
XFILLER_0_87_1291 VPWR VGND VPWR VGND sky130_ef_sc_hd__decap_12
XFILLER_0_223_1033 VPWR VGND VPWR VGND sky130_ef_sc_hd__decap_12
XFILLER_0_48_1275 VGND VGND VPWR VPWR sky130_fd_sc_hd__decap_6
XFILLER_0_223_1077 VPWR VGND VPWR VGND sky130_ef_sc_hd__decap_12
XFILLER_0_226_600 VPWR VGND VPWR VGND sky130_ef_sc_hd__decap_12
XFILLER_0_1_473 VPWR VGND VPWR VGND sky130_ef_sc_hd__decap_12
XFILLER_0_226_622 VGND VGND VPWR VPWR sky130_fd_sc_hd__fill_2
XFILLER_0_226_666 VGND VGND VPWR VPWR sky130_fd_sc_hd__decap_6
XFILLER_0_226_688 VPWR VGND VPWR VGND sky130_ef_sc_hd__decap_12
XFILLER_0_213_305 VPWR VGND VPWR VGND sky130_ef_sc_hd__decap_12
XFILLER_0_158_1263 VPWR VGND VPWR VGND sky130_ef_sc_hd__decap_12
XFILLER_0_119_1225 VPWR VGND VPWR VGND sky130_ef_sc_hd__decap_12
XFILLER_0_213_349 VPWR VGND VPWR VGND sky130_ef_sc_hd__decap_12
XFILLER_0_94_1251 VPWR VGND VPWR VGND sky130_ef_sc_hd__decap_12
XFILLER_0_9_1309 VGND VGND VPWR VPWR sky130_fd_sc_hd__fill_1
XFILLER_0_55_1213 VPWR VGND VPWR VGND sky130_ef_sc_hd__decap_12
XTAP_2107 VGND VPWR sky130_fd_sc_hd__tapvpwrvgnd_1
XFILLER_0_222_861 VGND VGND VPWR VPWR sky130_fd_sc_hd__decap_6
XFILLER_0_94_1295 VPWR VGND VPWR VGND sky130_ef_sc_hd__decap_12
XTAP_2129 VGND VPWR sky130_fd_sc_hd__tapvpwrvgnd_1
XTAP_2118 VGND VPWR sky130_fd_sc_hd__tapvpwrvgnd_1
XTAP_1406 VGND VPWR sky130_fd_sc_hd__tapvpwrvgnd_1
XFILLER_0_139_629 VPWR VGND VPWR VGND sky130_ef_sc_hd__decap_12
XTAP_1417 VGND VPWR sky130_fd_sc_hd__tapvpwrvgnd_1
XTAP_1428 VGND VPWR sky130_fd_sc_hd__tapvpwrvgnd_1
XTAP_1439 VGND VPWR sky130_fd_sc_hd__tapvpwrvgnd_1
XFILLER_0_7_1033 VGND VGND VPWR VPWR sky130_fd_sc_hd__decap_3
XFILLER_0_55_1279 VPWR VGND VPWR VGND sky130_ef_sc_hd__decap_12
XFILLER_0_221_393 VPWR VGND VPWR VGND sky130_ef_sc_hd__decap_12
XFILLER_0_37_605 VPWR VGND VPWR VGND sky130_ef_sc_hd__decap_12
XFILLER_0_7_1077 VPWR VGND VPWR VGND sky130_ef_sc_hd__decap_12
XFILLER_0_165_1201 VPWR VGND VPWR VGND sky130_ef_sc_hd__decap_12
XFILLER_0_52_619 VPWR VGND VPWR VGND sky130_ef_sc_hd__decap_12
XFILLER_0_162_643 VPWR VGND VPWR VGND sky130_ef_sc_hd__decap_12
XFILLER_0_107_559 VGND VGND VPWR VPWR sky130_fd_sc_hd__fill_1
XFILLER_0_165_1267 VPWR VGND VPWR VGND sky130_ef_sc_hd__decap_12
XFILLER_0_66_1331 VGND VGND VPWR VPWR sky130_fd_sc_hd__decap_6
XFILLER_0_206_1275 VGND VGND VPWR VPWR sky130_fd_sc_hd__decap_6
XFILLER_0_62_1239 VPWR VGND VPWR VGND sky130_ef_sc_hd__decap_12
XFILLER_0_216_121 VPWR VGND VPWR VGND sky130_ef_sc_hd__decap_12
XFILLER_0_102_1251 VPWR VGND VPWR VGND sky130_ef_sc_hd__decap_12
XFILLER_0_216_165 VPWR VGND VPWR VGND sky130_ef_sc_hd__decap_12
XFILLER_0_137_1303 VGND VGND VPWR VPWR sky130_fd_sc_hd__decap_6
XFILLER_0_102_1295 VPWR VGND VPWR VGND sky130_ef_sc_hd__decap_12
XFILLER_0_172_1227 VPWR VGND VPWR VGND sky130_ef_sc_hd__decap_12
XTAP_2630 VGND VPWR sky130_fd_sc_hd__tapvpwrvgnd_1
XFILLER_0_206_41 VGND VGND VPWR VPWR sky130_fd_sc_hd__decap_8
XFILLER_0_73_1335 VGND VGND VPWR VPWR sky130_fd_sc_hd__decap_8
XFILLER_0_213_1213 VPWR VGND VPWR VGND sky130_ef_sc_hd__decap_12
XTAP_2652 VGND VPWR sky130_fd_sc_hd__tapvpwrvgnd_1
XTAP_2663 VGND VPWR sky130_fd_sc_hd__tapvpwrvgnd_1
XTAP_2641 VGND VPWR sky130_fd_sc_hd__tapvpwrvgnd_1
XFILLER_0_34_1319 VPWR VGND VPWR VGND sky130_ef_sc_hd__decap_12
XFILLER_0_213_1257 VPWR VGND VPWR VGND sky130_ef_sc_hd__decap_12
XTAP_2696 VGND VPWR sky130_fd_sc_hd__tapvpwrvgnd_1
XTAP_2674 VGND VPWR sky130_fd_sc_hd__tapvpwrvgnd_1
XTAP_2685 VGND VPWR sky130_fd_sc_hd__tapvpwrvgnd_1
XTAP_1951 VGND VPWR sky130_fd_sc_hd__tapvpwrvgnd_1
XTAP_1940 VGND VPWR sky130_fd_sc_hd__tapvpwrvgnd_1
XFILLER_0_51_27 VPWR VGND VPWR VGND sky130_ef_sc_hd__decap_12
XFILLER_0_28_605 VPWR VGND VPWR VGND sky130_ef_sc_hd__decap_12
XFILLER_0_142_29 VPWR VGND VPWR VGND sky130_ef_sc_hd__decap_12
XTAP_1995 VGND VPWR sky130_fd_sc_hd__tapvpwrvgnd_1
XTAP_1973 VGND VPWR sky130_fd_sc_hd__tapvpwrvgnd_1
XFILLER_0_95_593 VPWR VGND VPWR VGND sky130_ef_sc_hd__decap_12
XTAP_1962 VGND VPWR sky130_fd_sc_hd__tapvpwrvgnd_1
XTAP_1984 VGND VPWR sky130_fd_sc_hd__tapvpwrvgnd_1
XFILLER_0_183_1323 VPWR VGND VPWR VGND sky130_ef_sc_hd__decap_12
XFILLER_0_144_1307 VPWR VGND VPWR VGND sky130_ef_sc_hd__decap_12
XFILLER_0_113_529 VPWR VGND VPWR VGND sky130_ef_sc_hd__decap_12
XFILLER_0_3_727 VGND VGND VPWR VPWR sky130_fd_sc_hd__fill_1
XFILLER_0_51_641 VGND VGND VPWR VPWR sky130_fd_sc_hd__decap_4
XFILLER_0_106_581 VGND VGND VPWR VPWR sky130_fd_sc_hd__decap_6
XFILLER_0_80_1339 VGND VGND VPWR VPWR sky130_fd_sc_hd__decap_4
XFILLER_0_220_1217 VPWR VGND VPWR VGND sky130_ef_sc_hd__decap_12
XFILLER_0_167_15 VPWR VGND VPWR VGND sky130_ef_sc_hd__decap_12
XFILLER_0_208_655 VGND VGND VPWR VPWR sky130_fd_sc_hd__decap_4
XFILLER_0_78_1213 VPWR VGND VPWR VGND sky130_ef_sc_hd__decap_12
XFILLER_0_183_47 VGND VGND VPWR VPWR sky130_fd_sc_hd__fill_1
XFILLER_0_211_809 VPWR VGND VPWR VGND sky130_ef_sc_hd__decap_12
XFILLER_0_116_41 VGND VGND VPWR VPWR sky130_fd_sc_hd__decap_8
XFILLER_0_8_1331 VGND VGND VPWR VPWR sky130_fd_sc_hd__decap_6
XFILLER_0_188_1201 VPWR VGND VPWR VGND sky130_ef_sc_hd__decap_12
XFILLER_0_114_1133 VPWR VGND VPWR VGND sky130_ef_sc_hd__decap_12
XFILLER_0_19_605 VPWR VGND VPWR VGND sky130_ef_sc_hd__decap_12
XFILLER_0_4_1217 VPWR VGND VPWR VGND sky130_ef_sc_hd__decap_12
XFILLER_0_114_1177 VPWR VGND VPWR VGND sky130_ef_sc_hd__decap_12
XFILLER_0_86_593 VPWR VGND VPWR VGND sky130_ef_sc_hd__decap_12
XFILLER_0_144_643 VPWR VGND VPWR VGND sky130_ef_sc_hd__decap_12
XFILLER_0_34_619 VPWR VGND VPWR VGND sky130_ef_sc_hd__decap_12
XFILLER_0_104_529 VGND VGND VPWR VPWR sky130_fd_sc_hd__decap_3
XFILLER_0_81_3 VPWR VGND VPWR VGND sky130_ef_sc_hd__decap_12
XFILLER_0_6_587 VGND VGND VPWR VPWR sky130_fd_sc_hd__fill_1
XFILLER_0_219_909 VPWR VGND VPWR VGND sky130_ef_sc_hd__decap_12
XFILLER_0_2_793 VPWR VGND VPWR VGND sky130_ef_sc_hd__decap_12
XFILLER_0_218_419 VGND VGND VPWR VPWR sky130_fd_sc_hd__fill_1
XFILLER_0_1_281 VPWR VGND VPWR VGND sky130_ef_sc_hd__decap_12
XFILLER_0_22_1201 VPWR VGND VPWR VGND sky130_ef_sc_hd__decap_12
XFILLER_0_10_593 VPWR VGND VPWR VGND sky130_ef_sc_hd__decap_12
XFILLER_0_195_1249 VGND VGND VPWR VPWR sky130_fd_sc_hd__decap_4
XFILLER_0_214_625 VPWR VGND VPWR VGND sky130_ef_sc_hd__decap_12
XFILLER_0_5_93 VPWR VGND VPWR VGND sky130_ef_sc_hd__decap_12
XFILLER_0_213_113 VPWR VGND VPWR VGND sky130_ef_sc_hd__decap_12
XFILLER_0_214_669 VPWR VGND VPWR VGND sky130_ef_sc_hd__decap_12
XFILLER_0_210_853 VPWR VGND VPWR VGND sky130_ef_sc_hd__decap_12
XTAP_1247 VGND VPWR sky130_fd_sc_hd__tapvpwrvgnd_1
XTAP_1236 VGND VPWR sky130_fd_sc_hd__tapvpwrvgnd_1
XTAP_1225 VGND VPWR sky130_fd_sc_hd__tapvpwrvgnd_1
XFILLER_0_210_897 VGND VGND VPWR VPWR sky130_fd_sc_hd__decap_8
XTAP_1269 VGND VPWR sky130_fd_sc_hd__tapvpwrvgnd_1
XFILLER_0_77_593 VPWR VGND VPWR VGND sky130_ef_sc_hd__decap_12
XTAP_1258 VGND VPWR sky130_fd_sc_hd__tapvpwrvgnd_1
XFILLER_0_108_813 VPWR VGND VPWR VGND sky130_ef_sc_hd__decap_12
XFILLER_0_33_641 VGND VGND VPWR VPWR sky130_fd_sc_hd__decap_4
XFILLER_0_208_1337 VGND VGND VPWR VPWR sky130_fd_sc_hd__fill_1
XANTENNA_input65_A psum_col0_in[9] VGND VGND VPWR VPWR sky130_fd_sc_hd__diode_2
XFILLER_0_104_1313 VGND VGND VPWR VPWR sky130_fd_sc_hd__decap_3
XFILLER_0_217_441 VGND VGND VPWR VPWR sky130_fd_sc_hd__decap_6
XFILLER_0_46_49 VGND VGND VPWR VPWR sky130_fd_sc_hd__fill_1
XFILLER_0_46_27 VGND VGND VPWR VPWR sky130_fd_sc_hd__fill_1
XFILLER_0_205_647 VPWR VGND VPWR VGND sky130_ef_sc_hd__decap_12
XFILLER_0_217_485 VPWR VGND VPWR VGND sky130_ef_sc_hd__decap_12
XANTENNA_output221_A net221 VGND VGND VPWR VPWR sky130_fd_sc_hd__diode_2
XFILLER_0_62_15 VPWR VGND VPWR VGND sky130_ef_sc_hd__decap_12
XFILLER_0_38_1263 VPWR VGND VPWR VGND sky130_ef_sc_hd__decap_12
XFILLER_0_153_39 VGND VGND VPWR VPWR sky130_fd_sc_hd__decap_8
XFILLER_0_213_1021 VPWR VGND VPWR VGND sky130_ef_sc_hd__decap_12
XTAP_2471 VGND VPWR sky130_fd_sc_hd__tapvpwrvgnd_1
XTAP_2460 VGND VPWR sky130_fd_sc_hd__tapvpwrvgnd_1
XFILLER_0_213_1065 VPWR VGND VPWR VGND sky130_ef_sc_hd__decap_12
XTAP_2493 VGND VPWR sky130_fd_sc_hd__tapvpwrvgnd_1
XTAP_2482 VGND VPWR sky130_fd_sc_hd__tapvpwrvgnd_1
XFILLER_0_68_593 VPWR VGND VPWR VGND sky130_ef_sc_hd__decap_12
XTAP_1770 VGND VPWR sky130_fd_sc_hd__tapvpwrvgnd_1
XTAP_1792 VGND VPWR sky130_fd_sc_hd__tapvpwrvgnd_1
XTAP_1781 VGND VPWR sky130_fd_sc_hd__tapvpwrvgnd_1
XFILLER_0_126_643 VPWR VGND VPWR VGND sky130_ef_sc_hd__decap_12
XFILLER_0_16_619 VPWR VGND VPWR VGND sky130_ef_sc_hd__decap_12
XFILLER_0_148_1251 VPWR VGND VPWR VGND sky130_ef_sc_hd__decap_12
XFILLER_0_148_1295 VPWR VGND VPWR VGND sky130_ef_sc_hd__decap_12
XFILLER_0_109_1213 VPWR VGND VPWR VGND sky130_ef_sc_hd__decap_12
XFILLER_0_45_1201 VPWR VGND VPWR VGND sky130_ef_sc_hd__decap_12
XFILLER_0_113_337 VPWR VGND VPWR VGND sky130_ef_sc_hd__decap_12
XFILLER_0_178_25 VGND VGND VPWR VPWR sky130_fd_sc_hd__decap_3
XFILLER_0_109_1257 VPWR VGND VPWR VGND sky130_ef_sc_hd__decap_12
XFILLER_0_87_34 VPWR VGND VPWR VGND sky130_ef_sc_hd__decap_12
XFILLER_0_84_1283 VPWR VGND VPWR VGND sky130_ef_sc_hd__decap_12
XFILLER_0_224_1161 VPWR VGND VPWR VGND sky130_ef_sc_hd__decap_12
XFILLER_0_45_1267 VPWR VGND VPWR VGND sky130_ef_sc_hd__decap_12
XFILLER_0_224_923 VGND VGND VPWR VPWR sky130_fd_sc_hd__fill_1
Xinput1 act_row0_in[0] VGND VGND VPWR VPWR net1 sky130_fd_sc_hd__clkbuf_4
XFILLER_0_155_1255 VPWR VGND VPWR VGND sky130_ef_sc_hd__decap_12
XFILLER_0_211_617 VPWR VGND VPWR VGND sky130_ef_sc_hd__decap_12
XFILLER_0_116_1239 VPWR VGND VPWR VGND sky130_ef_sc_hd__decap_12
XFILLER_0_17_1303 VGND VGND VPWR VPWR sky130_fd_sc_hd__decap_6
XFILLER_0_52_1227 VPWR VGND VPWR VGND sky130_ef_sc_hd__decap_12
XFILLER_0_59_593 VPWR VGND VPWR VGND sky130_ef_sc_hd__decap_12
XPHY_319 VGND VGND VPWR VPWR sky130_fd_sc_hd__decap_3
XPHY_308 VGND VGND VPWR VPWR sky130_fd_sc_hd__decap_3
XFILLER_0_108_109 VPWR VGND VPWR VGND sky130_ef_sc_hd__decap_12
XFILLER_0_7_841 VPWR VGND VPWR VGND sky130_ef_sc_hd__decap_12
XFILLER_0_127_1335 VGND VGND VPWR VPWR sky130_fd_sc_hd__decap_8
XFILLER_0_15_641 VGND VGND VPWR VPWR sky130_fd_sc_hd__decap_4
XFILLER_0_104_337 VPWR VGND VPWR VGND sky130_ef_sc_hd__decap_12
XFILLER_0_63_1323 VPWR VGND VPWR VGND sky130_ef_sc_hd__decap_12
XFILLER_0_203_1201 VPWR VGND VPWR VGND sky130_ef_sc_hd__decap_12
XFILLER_0_30_655 VGND VGND VPWR VPWR sky130_fd_sc_hd__decap_4
XFILLER_0_24_1307 VPWR VGND VPWR VGND sky130_ef_sc_hd__decap_12
XFILLER_0_203_1267 VPWR VGND VPWR VGND sky130_ef_sc_hd__decap_12
XFILLER_0_215_945 VGND VGND VPWR VPWR sky130_fd_sc_hd__decap_6
XFILLER_0_214_433 VPWR VGND VPWR VGND sky130_ef_sc_hd__decap_12
XFILLER_0_173_1311 VPWR VGND VPWR VGND sky130_ef_sc_hd__decap_12
XFILLER_0_215_989 VPWR VGND VPWR VGND sky130_ef_sc_hd__decap_12
XFILLER_0_202_617 VGND VGND VPWR VPWR sky130_fd_sc_hd__fill_1
XFILLER_0_214_477 VPWR VGND VPWR VGND sky130_ef_sc_hd__decap_12
XFILLER_0_134_1339 VGND VGND VPWR VPWR sky130_fd_sc_hd__decap_4
XFILLER_0_214_1341 VGND VGND VPWR VPWR sky130_fd_sc_hd__fill_1
XFILLER_0_210_1205 VPWR VGND VPWR VGND sky130_ef_sc_hd__decap_12
XPHY_820 VGND VGND VPWR VPWR sky130_fd_sc_hd__decap_3
XFILLER_0_32_29 VPWR VGND VPWR VGND sky130_ef_sc_hd__decap_12
XPHY_853 VGND VGND VPWR VPWR sky130_fd_sc_hd__decap_3
XPHY_831 VGND VGND VPWR VPWR sky130_fd_sc_hd__decap_3
XPHY_842 VGND VGND VPWR VPWR sky130_fd_sc_hd__decap_3
XPHY_864 VGND VGND VPWR VPWR sky130_fd_sc_hd__decap_3
XPHY_886 VGND VGND VPWR VPWR sky130_fd_sc_hd__decap_3
XPHY_875 VGND VGND VPWR VPWR sky130_fd_sc_hd__decap_3
XFILLER_0_108_643 VGND VGND VPWR VPWR sky130_fd_sc_hd__fill_1
XFILLER_0_68_1201 VPWR VGND VPWR VGND sky130_ef_sc_hd__decap_12
XPHY_897 VGND VGND VPWR VPWR sky130_fd_sc_hd__decap_3
XFILLER_0_180_1337 VGND VGND VPWR VPWR sky130_fd_sc_hd__fill_1
XFILLER_0_221_1301 VPWR VGND VPWR VGND sky130_ef_sc_hd__decap_12
XFILLER_0_104_893 VGND VGND VPWR VPWR sky130_fd_sc_hd__decap_3
XFILLER_0_0_527 VGND VGND VPWR VPWR sky130_fd_sc_hd__decap_4
XFILLER_0_0_505 VGND VGND VPWR VPWR sky130_fd_sc_hd__decap_4
XFILLER_0_21_655 VGND VGND VPWR VPWR sky130_fd_sc_hd__fill_2
XFILLER_0_110_307 VGND VGND VPWR VPWR sky130_fd_sc_hd__fill_1
XFILLER_0_104_1121 VPWR VGND VPWR VGND sky130_ef_sc_hd__decap_12
XFILLER_0_57_15 VPWR VGND VPWR VGND sky130_ef_sc_hd__decap_12
XFILLER_0_225_709 VPWR VGND VPWR VGND sky130_ef_sc_hd__decap_12
XFILLER_0_217_293 VPWR VGND VPWR VGND sky130_ef_sc_hd__decap_12
XFILLER_0_75_1249 VGND VGND VPWR VPWR sky130_fd_sc_hd__decap_4
XFILLER_0_164_49 VGND VGND VPWR VPWR sky130_fd_sc_hd__fill_1
XFILLER_0_88_655 VGND VGND VPWR VPWR sky130_fd_sc_hd__decap_4
XFILLER_0_220_469 VGND VGND VPWR VPWR sky130_fd_sc_hd__decap_6
XFILLER_0_180_15 VPWR VGND VPWR VGND sky130_ef_sc_hd__decap_12
XFILLER_0_5_1301 VPWR VGND VPWR VGND sky130_ef_sc_hd__decap_12
XTAP_2290 VGND VPWR sky130_fd_sc_hd__tapvpwrvgnd_1
XFILLER_0_8_605 VPWR VGND VPWR VGND sky130_ef_sc_hd__decap_12
XFILLER_0_111_1169 VGND VGND VPWR VPWR sky130_fd_sc_hd__decap_6
XFILLER_0_7_137 VGND VGND VPWR VPWR sky130_fd_sc_hd__decap_3
XFILLER_0_185_1237 VPWR VGND VPWR VGND sky130_ef_sc_hd__decap_12
XFILLER_0_189_13 VPWR VGND VPWR VGND sky130_ef_sc_hd__decap_12
XFILLER_0_4_811 VGND VGND VPWR VPWR sky130_fd_sc_hd__fill_1
XFILLER_0_109_1021 VPWR VGND VPWR VGND sky130_ef_sc_hd__decap_12
XFILLER_0_114_613 VGND VGND VPWR VPWR sky130_fd_sc_hd__decap_3
XFILLER_0_98_22 VGND VGND VPWR VPWR sky130_fd_sc_hd__decap_6
XFILLER_0_114_657 VPWR VGND VPWR VGND sky130_ef_sc_hd__decap_12
XFILLER_0_226_1289 VGND VGND VPWR VPWR sky130_fd_sc_hd__fill_2
XFILLER_0_109_1065 VPWR VGND VPWR VGND sky130_ef_sc_hd__decap_12
XFILLER_0_12_655 VGND VGND VPWR VPWR sky130_fd_sc_hd__decap_4
XFILLER_0_113_167 VGND VGND VPWR VPWR sky130_fd_sc_hd__fill_1
XFILLER_0_44_3 VPWR VGND VPWR VGND sky130_ef_sc_hd__decap_12
XFILLER_0_212_937 VPWR VGND VPWR VGND sky130_ef_sc_hd__decap_12
XFILLER_0_196_605 VPWR VGND VPWR VGND sky130_ef_sc_hd__decap_12
XFILLER_0_211_447 VGND VGND VPWR VPWR sky130_fd_sc_hd__fill_1
XFILLER_0_2_83 VGND VGND VPWR VPWR sky130_fd_sc_hd__fill_1
XFILLER_0_79_655 VGND VGND VPWR VPWR sky130_fd_sc_hd__fill_2
XFILLER_0_220_981 VPWR VGND VPWR VGND sky130_ef_sc_hd__decap_12
XPHY_105 VGND VGND VPWR VPWR sky130_fd_sc_hd__decap_3
XPHY_116 VGND VGND VPWR VPWR sky130_fd_sc_hd__decap_3
XPHY_149 VGND VGND VPWR VPWR sky130_fd_sc_hd__decap_3
XPHY_127 VGND VGND VPWR VPWR sky130_fd_sc_hd__decap_3
XPHY_138 VGND VGND VPWR VPWR sky130_fd_sc_hd__decap_3
XFILLER_0_109_429 VPWR VGND VPWR VGND sky130_ef_sc_hd__decap_12
XFILLER_0_120_605 VPWR VGND VPWR VGND sky130_ef_sc_hd__decap_12
XFILLER_0_28_1251 VPWR VGND VPWR VGND sky130_ef_sc_hd__decap_12
XFILLER_0_219_503 VGND VGND VPWR VPWR sky130_fd_sc_hd__fill_1
XFILLER_0_28_1295 VPWR VGND VPWR VGND sky130_ef_sc_hd__decap_12
XFILLER_0_140_1343 VGND VGND VPWR VPWR sky130_fd_sc_hd__fill_1
XFILLER_0_98_1227 VPWR VGND VPWR VGND sky130_ef_sc_hd__decap_12
Xoutput190 net190 VGND VGND VPWR VPWR psum_col0_out[3] sky130_fd_sc_hd__clkbuf_4
XFILLER_0_215_753 VPWR VGND VPWR VGND sky130_ef_sc_hd__decap_12
XANTENNA_input28_A act_row1_in[5] VGND VGND VPWR VPWR sky130_fd_sc_hd__diode_2
XFILLER_0_215_797 VPWR VGND VPWR VGND sky130_ef_sc_hd__decap_12
XFILLER_0_187_605 VPWR VGND VPWR VGND sky130_ef_sc_hd__decap_12
XFILLER_0_138_1283 VPWR VGND VPWR VGND sky130_ef_sc_hd__decap_12
XFILLER_0_214_41 VPWR VGND VPWR VGND sky130_ef_sc_hd__decap_12
XFILLER_0_43_39 VGND VGND VPWR VPWR sky130_fd_sc_hd__decap_8
XPHY_7 VGND VGND VPWR VPWR sky130_fd_sc_hd__decap_3
XFILLER_0_35_1255 VPWR VGND VPWR VGND sky130_ef_sc_hd__decap_12
XFILLER_0_85_647 VPWR VGND VPWR VGND sky130_ef_sc_hd__decap_12
XFILLER_0_210_1057 VGND VGND VPWR VPWR sky130_fd_sc_hd__fill_1
XFILLER_0_214_85 VPWR VGND VPWR VGND sky130_ef_sc_hd__decap_12
XPHY_661 VGND VGND VPWR VPWR sky130_fd_sc_hd__decap_3
XANTENNA_u_pe11_weight_in[5] net160 VGND VGND VPWR VPWR sky130_fd_sc_hd__diode_2
XPHY_650 VGND VGND VPWR VPWR sky130_fd_sc_hd__decap_3
XFILLER_0_150_29 VPWR VGND VPWR VGND sky130_ef_sc_hd__decap_12
XPHY_672 VGND VGND VPWR VPWR sky130_fd_sc_hd__decap_3
XPHY_694 VGND VGND VPWR VPWR sky130_fd_sc_hd__decap_3
XPHY_683 VGND VGND VPWR VPWR sky130_fd_sc_hd__decap_3
XFILLER_0_0_1253 VGND VGND VPWR VPWR sky130_fd_sc_hd__decap_4
XFILLER_0_184_1281 VGND VGND VPWR VPWR sky130_fd_sc_hd__fill_1
XFILLER_0_0_1275 VGND VGND VPWR VPWR sky130_fd_sc_hd__fill_2
XFILLER_0_0_1297 VGND VGND VPWR VPWR sky130_fd_sc_hd__fill_2
XFILLER_0_106_1205 VPWR VGND VPWR VGND sky130_ef_sc_hd__decap_12
XFILLER_0_159_27 VPWR VGND VPWR VGND sky130_ef_sc_hd__decap_12
XFILLER_0_0_335 VGND VGND VPWR VPWR sky130_fd_sc_hd__fill_1
XFILLER_0_81_1253 VGND VGND VPWR VPWR sky130_fd_sc_hd__fill_1
XFILLER_0_221_1175 VGND VGND VPWR VPWR sky130_fd_sc_hd__fill_1
XFILLER_0_225_517 VPWR VGND VPWR VGND sky130_ef_sc_hd__decap_12
XFILLER_0_187_3 VPWR VGND VPWR VGND sky130_ef_sc_hd__decap_12
XFILLER_0_175_37 VGND VGND VPWR VPWR sky130_fd_sc_hd__decap_8
XFILLER_0_108_53 VPWR VGND VPWR VGND sky130_ef_sc_hd__decap_12
XFILLER_0_178_605 VPWR VGND VPWR VGND sky130_ef_sc_hd__decap_12
XFILLER_0_117_1323 VPWR VGND VPWR VGND sky130_ef_sc_hd__decap_12
XFILLER_0_220_233 VPWR VGND VPWR VGND sky130_ef_sc_hd__decap_12
XFILLER_0_191_47 VGND VGND VPWR VPWR sky130_fd_sc_hd__fill_1
XFILLER_0_152_1225 VGND VGND VPWR VPWR sky130_fd_sc_hd__fill_1
XFILLER_0_53_1311 VPWR VGND VPWR VGND sky130_ef_sc_hd__decap_12
XFILLER_0_108_97 VPWR VGND VPWR VGND sky130_ef_sc_hd__decap_12
XFILLER_0_124_41 VGND VGND VPWR VPWR sky130_fd_sc_hd__decap_8
XFILLER_0_220_277 VPWR VGND VPWR VGND sky130_ef_sc_hd__decap_12
XFILLER_0_14_1339 VGND VGND VPWR VPWR sky130_fd_sc_hd__decap_4
XFILLER_0_91_617 VPWR VGND VPWR VGND sky130_ef_sc_hd__decap_12
XFILLER_0_5_1175 VGND VGND VPWR VPWR sky130_fd_sc_hd__fill_1
XFILLER_0_114_421 VPWR VGND VPWR VGND sky130_ef_sc_hd__decap_12
Xinput81 psum_col1_in[23] VGND VGND VPWR VPWR net81 sky130_fd_sc_hd__dlymetal6s2s_1
Xinput70 psum_col1_in[13] VGND VGND VPWR VPWR net70 sky130_fd_sc_hd__buf_1
XFILLER_0_163_1343 VGND VGND VPWR VPWR sky130_fd_sc_hd__fill_1
XFILLER_0_102_605 VPWR VGND VPWR VGND sky130_ef_sc_hd__decap_12
Xinput92 psum_col1_in[4] VGND VGND VPWR VPWR net92 sky130_fd_sc_hd__buf_1
XFILLER_0_60_1337 VGND VGND VPWR VPWR sky130_fd_sc_hd__fill_1
XFILLER_0_110_693 VGND VGND VPWR VPWR sky130_fd_sc_hd__decap_6
XFILLER_0_212_701 VPWR VGND VPWR VGND sky130_ef_sc_hd__decap_12
XFILLER_0_169_605 VPWR VGND VPWR VGND sky130_ef_sc_hd__decap_12
XFILLER_0_131_1309 VGND VGND VPWR VPWR sky130_fd_sc_hd__fill_1
XFILLER_0_184_619 VPWR VGND VPWR VGND sky130_ef_sc_hd__decap_12
XFILLER_0_67_647 VGND VGND VPWR VPWR sky130_fd_sc_hd__decap_8
XFILLER_0_82_617 VGND VGND VPWR VPWR sky130_fd_sc_hd__fill_1
XFILLER_0_109_237 VPWR VGND VPWR VGND sky130_ef_sc_hd__decap_12
XFILLER_0_129_1249 VGND VGND VPWR VPWR sky130_fd_sc_hd__decap_4
XFILLER_0_65_1237 VPWR VGND VPWR VGND sky130_ef_sc_hd__decap_12
XFILLER_0_160_593 VPWR VGND VPWR VGND sky130_ef_sc_hd__decap_12
XFILLER_0_175_1225 VPWR VGND VPWR VGND sky130_ef_sc_hd__decap_12
XFILLER_0_215_561 VPWR VGND VPWR VGND sky130_ef_sc_hd__decap_12
XFILLER_0_54_27 VGND VGND VPWR VPWR sky130_fd_sc_hd__fill_1
XFILLER_0_54_49 VGND VGND VPWR VPWR sky130_fd_sc_hd__fill_1
XFILLER_0_183_641 VGND VGND VPWR VPWR sky130_fd_sc_hd__decap_4
XFILLER_0_151_1291 VPWR VGND VPWR VGND sky130_ef_sc_hd__decap_12
XFILLER_0_112_1253 VGND VGND VPWR VPWR sky130_fd_sc_hd__decap_6
XFILLER_0_73_617 VPWR VGND VPWR VGND sky130_ef_sc_hd__decap_12
XFILLER_0_2_1315 VGND VGND VPWR VPWR sky130_fd_sc_hd__fill_1
XFILLER_0_186_1343 VGND VGND VPWR VPWR sky130_fd_sc_hd__fill_1
XFILLER_0_6_917 VGND VGND VPWR VPWR sky130_fd_sc_hd__decap_6
XPHY_480 VGND VGND VPWR VPWR sky130_fd_sc_hd__decap_3
XFILLER_0_112_1297 VPWR VGND VPWR VGND sky130_ef_sc_hd__decap_12
XPHY_491 VGND VGND VPWR VPWR sky130_fd_sc_hd__decap_3
XFILLER_0_5_405 VPWR VGND VPWR VGND sky130_ef_sc_hd__decap_12
XANTENNA_u_pe01_psum_in[21] net79 VGND VGND VPWR VPWR sky130_fd_sc_hd__diode_2
XPHY_1090 VGND VGND VPWR VPWR sky130_fd_sc_hd__decap_3
XFILLER_0_5_449 VPWR VGND VPWR VGND sky130_ef_sc_hd__decap_12
XFILLER_0_112_925 VPWR VGND VPWR VGND sky130_ef_sc_hd__decap_12
XFILLER_0_102_3 VPWR VGND VPWR VGND sky130_ef_sc_hd__decap_12
XFILLER_0_106_1035 VGND VGND VPWR VPWR sky130_fd_sc_hd__fill_1
XFILLER_0_151_593 VPWR VGND VPWR VGND sky130_ef_sc_hd__decap_12
XFILLER_0_110_65 VPWR VGND VPWR VGND sky130_ef_sc_hd__decap_12
XFILLER_0_193_1303 VGND VGND VPWR VPWR sky130_fd_sc_hd__decap_6
XFILLER_0_226_848 VGND VGND VPWR VPWR sky130_fd_sc_hd__decap_8
XFILLER_0_20_1343 VGND VGND VPWR VPWR sky130_fd_sc_hd__fill_1
XFILLER_0_90_1319 VPWR VGND VPWR VGND sky130_ef_sc_hd__decap_12
XFILLER_0_221_553 VGND VGND VPWR VPWR sky130_fd_sc_hd__decap_6
XFILLER_0_221_597 VPWR VGND VPWR VGND sky130_ef_sc_hd__decap_12
XFILLER_0_166_619 VPWR VGND VPWR VGND sky130_ef_sc_hd__decap_12
XFILLER_0_49_647 VGND VGND VPWR VPWR sky130_fd_sc_hd__decap_8
XFILLER_0_18_1283 VPWR VGND VPWR VGND sky130_ef_sc_hd__decap_12
XFILLER_0_130_1331 VGND VGND VPWR VPWR sky130_fd_sc_hd__decap_6
XFILLER_0_64_617 VGND VGND VPWR VPWR sky130_fd_sc_hd__fill_1
XFILLER_0_142_593 VPWR VGND VPWR VGND sky130_ef_sc_hd__decap_12
XFILLER_0_64_1281 VGND VGND VPWR VPWR sky130_fd_sc_hd__fill_1
XFILLER_0_198_1225 VGND VGND VPWR VPWR sky130_fd_sc_hd__fill_1
XFILLER_0_99_1311 VPWR VGND VPWR VGND sky130_ef_sc_hd__decap_12
XTAP_2801 VGND VPWR sky130_fd_sc_hd__tapvpwrvgnd_1
XTAP_2812 VGND VPWR sky130_fd_sc_hd__tapvpwrvgnd_1
XFILLER_0_212_531 VGND VGND VPWR VPWR sky130_fd_sc_hd__fill_1
XTAP_2823 VGND VPWR sky130_fd_sc_hd__tapvpwrvgnd_1
XTAP_2845 VGND VPWR sky130_fd_sc_hd__tapvpwrvgnd_1
XTAP_2834 VGND VPWR sky130_fd_sc_hd__tapvpwrvgnd_1
XFILLER_0_135_1253 VGND VGND VPWR VPWR sky130_fd_sc_hd__fill_1
XTAP_2867 VGND VPWR sky130_fd_sc_hd__tapvpwrvgnd_1
XTAP_2878 VGND VPWR sky130_fd_sc_hd__tapvpwrvgnd_1
XTAP_2856 VGND VPWR sky130_fd_sc_hd__tapvpwrvgnd_1
XTAP_2889 VGND VPWR sky130_fd_sc_hd__tapvpwrvgnd_1
XFILLER_0_55_617 VPWR VGND VPWR VGND sky130_ef_sc_hd__decap_12
XFILLER_0_32_1225 VGND VGND VPWR VPWR sky130_fd_sc_hd__fill_1
XFILLER_0_165_641 VGND VGND VPWR VPWR sky130_fd_sc_hd__decap_4
XANTENNA_input95_A psum_col1_in[7] VGND VGND VPWR VPWR sky130_fd_sc_hd__diode_2
XFILLER_0_40_29 VPWR VGND VPWR VGND sky130_ef_sc_hd__decap_12
XFILLER_0_180_655 VGND VGND VPWR VPWR sky130_fd_sc_hd__decap_4
XFILLER_0_3_909 VPWR VGND VPWR VGND sky130_ef_sc_hd__decap_12
XFILLER_0_2_419 VGND VGND VPWR VPWR sky130_fd_sc_hd__fill_1
XFILLER_0_142_1213 VPWR VGND VPWR VGND sky130_ef_sc_hd__decap_12
XFILLER_0_107_1333 VGND VGND VPWR VPWR sky130_fd_sc_hd__decap_3
XFILLER_0_133_593 VPWR VGND VPWR VGND sky130_ef_sc_hd__decap_12
XFILLER_0_105_273 VGND VGND VPWR VPWR sky130_fd_sc_hd__decap_6
XFILLER_0_43_1343 VGND VGND VPWR VPWR sky130_fd_sc_hd__fill_1
XFILLER_0_177_1309 VGND VGND VPWR VPWR sky130_fd_sc_hd__fill_1
XFILLER_0_65_15 VPWR VGND VPWR VGND sky130_ef_sc_hd__decap_12
XFILLER_0_4_29 VPWR VGND VPWR VGND sky130_ef_sc_hd__decap_12
XFILLER_0_218_1317 VPWR VGND VPWR VGND sky130_ef_sc_hd__decap_12
XFILLER_0_216_881 VPWR VGND VPWR VGND sky130_ef_sc_hd__decap_12
XFILLER_0_171_6 VGND VGND VPWR VPWR sky130_fd_sc_hd__fill_2
XFILLER_0_215_391 VGND VGND VPWR VPWR sky130_fd_sc_hd__fill_1
XFILLER_0_172_27 VGND VGND VPWR VPWR sky130_fd_sc_hd__fill_1
XFILLER_0_172_49 VGND VGND VPWR VPWR sky130_fd_sc_hd__fill_1
XFILLER_0_216_1085 VGND VGND VPWR VPWR sky130_fd_sc_hd__decap_6
XFILLER_0_148_619 VPWR VGND VPWR VGND sky130_ef_sc_hd__decap_12
XFILLER_0_81_47 VGND VGND VPWR VPWR sky130_fd_sc_hd__decap_3
XFILLER_0_105_10 VPWR VGND VPWR VGND sky130_ef_sc_hd__decap_12
XFILLER_0_14_41 VGND VGND VPWR VPWR sky130_fd_sc_hd__decap_8
XFILLER_0_46_617 VGND VGND VPWR VPWR sky130_fd_sc_hd__fill_1
XFILLER_0_105_54 VGND VGND VPWR VPWR sky130_fd_sc_hd__fill_2
XFILLER_0_112_1061 VPWR VGND VPWR VGND sky130_ef_sc_hd__decap_12
XFILLER_0_11_1309 VGND VGND VPWR VPWR sky130_fd_sc_hd__fill_1
XFILLER_0_6_725 VPWR VGND VPWR VGND sky130_ef_sc_hd__decap_12
XFILLER_0_171_655 VGND VGND VPWR VPWR sky130_fd_sc_hd__fill_2
XFILLER_0_6_769 VPWR VGND VPWR VGND sky130_ef_sc_hd__decap_12
XFILLER_0_5_279 VGND VGND VPWR VPWR sky130_fd_sc_hd__fill_1
XFILLER_0_223_1001 VGND VGND VPWR VPWR sky130_fd_sc_hd__decap_6
XFILLER_0_124_593 VPWR VGND VPWR VGND sky130_ef_sc_hd__decap_12
XFILLER_0_223_1045 VPWR VGND VPWR VGND sky130_ef_sc_hd__decap_12
XFILLER_0_112_755 VGND VGND VPWR VPWR sky130_fd_sc_hd__fill_1
XFILLER_0_1_441 VGND VGND VPWR VPWR sky130_fd_sc_hd__decap_6
XFILLER_0_223_1089 VPWR VGND VPWR VGND sky130_ef_sc_hd__decap_12
XFILLER_0_1_485 VPWR VGND VPWR VGND sky130_ef_sc_hd__decap_12
XFILLER_0_201_1343 VGND VGND VPWR VPWR sky130_fd_sc_hd__fill_1
XFILLER_0_226_612 VGND VGND VPWR VPWR sky130_fd_sc_hd__decap_4
XFILLER_0_226_645 VPWR VGND VPWR VGND sky130_ef_sc_hd__decap_12
XFILLER_0_225_111 VGND VGND VPWR VPWR sky130_fd_sc_hd__fill_1
XFILLER_0_197_1291 VPWR VGND VPWR VGND sky130_ef_sc_hd__decap_12
XFILLER_0_213_317 VPWR VGND VPWR VGND sky130_ef_sc_hd__decap_12
XFILLER_0_158_1275 VGND VGND VPWR VPWR sky130_fd_sc_hd__decap_6
XFILLER_0_119_1237 VPWR VGND VPWR VGND sky130_ef_sc_hd__decap_12
XFILLER_0_94_1263 VPWR VGND VPWR VGND sky130_ef_sc_hd__decap_12
XTAP_2108 VGND VPWR sky130_fd_sc_hd__tapvpwrvgnd_1
XTAP_2119 VGND VPWR sky130_fd_sc_hd__tapvpwrvgnd_1
XFILLER_0_55_1225 VPWR VGND VPWR VGND sky130_ef_sc_hd__decap_12
XFILLER_0_221_361 VPWR VGND VPWR VGND sky130_ef_sc_hd__decap_12
XTAP_1418 VGND VPWR sky130_fd_sc_hd__tapvpwrvgnd_1
XTAP_1407 VGND VPWR sky130_fd_sc_hd__tapvpwrvgnd_1
XTAP_1429 VGND VPWR sky130_fd_sc_hd__tapvpwrvgnd_1
XFILLER_0_37_617 VPWR VGND VPWR VGND sky130_ef_sc_hd__decap_12
XFILLER_0_147_641 VGND VGND VPWR VPWR sky130_fd_sc_hd__decap_4
XFILLER_0_7_1089 VGND VGND VPWR VPWR sky130_fd_sc_hd__decap_3
XFILLER_0_107_505 VPWR VGND VPWR VGND sky130_ef_sc_hd__decap_12
XFILLER_0_165_1213 VPWR VGND VPWR VGND sky130_ef_sc_hd__decap_12
XFILLER_0_162_655 VGND VGND VPWR VPWR sky130_fd_sc_hd__decap_4
XFILLER_0_31_1291 VPWR VGND VPWR VGND sky130_ef_sc_hd__decap_12
XFILLER_0_60_631 VPWR VGND VPWR VGND sky130_ef_sc_hd__decap_12
XFILLER_0_66_1343 VGND VGND VPWR VPWR sky130_fd_sc_hd__fill_1
XFILLER_0_165_1279 VPWR VGND VPWR VGND sky130_ef_sc_hd__decap_12
XFILLER_0_115_593 VPWR VGND VPWR VGND sky130_ef_sc_hd__decap_12
XFILLER_0_216_133 VGND VGND VPWR VPWR sky130_fd_sc_hd__decap_6
XFILLER_0_102_1263 VPWR VGND VPWR VGND sky130_ef_sc_hd__decap_12
XFILLER_0_176_1331 VGND VGND VPWR VPWR sky130_fd_sc_hd__decap_6
XFILLER_0_216_177 VPWR VGND VPWR VGND sky130_ef_sc_hd__decap_12
XFILLER_0_73_1303 VGND VGND VPWR VPWR sky130_fd_sc_hd__decap_6
XTAP_2620 VGND VPWR sky130_fd_sc_hd__tapvpwrvgnd_1
XFILLER_0_172_1239 VPWR VGND VPWR VGND sky130_ef_sc_hd__decap_12
XANTENNA_input10_A act_row0_in[3] VGND VGND VPWR VPWR sky130_fd_sc_hd__diode_2
XFILLER_0_213_1225 VGND VGND VPWR VPWR sky130_fd_sc_hd__decap_6
XTAP_2653 VGND VPWR sky130_fd_sc_hd__tapvpwrvgnd_1
XTAP_2631 VGND VPWR sky130_fd_sc_hd__tapvpwrvgnd_1
XFILLER_0_213_895 VGND VGND VPWR VPWR sky130_fd_sc_hd__fill_1
XTAP_2642 VGND VPWR sky130_fd_sc_hd__tapvpwrvgnd_1
XFILLER_0_213_1269 VPWR VGND VPWR VGND sky130_ef_sc_hd__decap_12
XTAP_2697 VGND VPWR sky130_fd_sc_hd__tapvpwrvgnd_1
XTAP_2675 VGND VPWR sky130_fd_sc_hd__tapvpwrvgnd_1
XTAP_2664 VGND VPWR sky130_fd_sc_hd__tapvpwrvgnd_1
XTAP_2686 VGND VPWR sky130_fd_sc_hd__tapvpwrvgnd_1
XTAP_1952 VGND VPWR sky130_fd_sc_hd__tapvpwrvgnd_1
XTAP_1930 VGND VPWR sky130_fd_sc_hd__tapvpwrvgnd_1
XTAP_1941 VGND VPWR sky130_fd_sc_hd__tapvpwrvgnd_1
XTAP_1974 VGND VPWR sky130_fd_sc_hd__tapvpwrvgnd_1
XTAP_1963 VGND VPWR sky130_fd_sc_hd__tapvpwrvgnd_1
XFILLER_0_51_39 VGND VGND VPWR VPWR sky130_fd_sc_hd__decap_8
XFILLER_0_28_617 VGND VGND VPWR VPWR sky130_fd_sc_hd__fill_1
XTAP_1985 VGND VPWR sky130_fd_sc_hd__tapvpwrvgnd_1
XFILLER_0_222_41 VPWR VGND VPWR VGND sky130_ef_sc_hd__decap_12
XTAP_1996 VGND VPWR sky130_fd_sc_hd__tapvpwrvgnd_1
XFILLER_0_222_85 VPWR VGND VPWR VGND sky130_ef_sc_hd__decap_12
XFILLER_0_153_655 VGND VGND VPWR VPWR sky130_fd_sc_hd__fill_2
XFILLER_0_10_1331 VGND VGND VPWR VPWR sky130_fd_sc_hd__decap_6
XFILLER_0_183_1335 VGND VGND VPWR VPWR sky130_fd_sc_hd__decap_8
XFILLER_0_144_1319 VPWR VGND VPWR VGND sky130_ef_sc_hd__decap_12
XFILLER_0_80_1307 VPWR VGND VPWR VGND sky130_ef_sc_hd__decap_12
XFILLER_0_220_1229 VPWR VGND VPWR VGND sky130_ef_sc_hd__decap_12
XFILLER_0_167_27 VPWR VGND VPWR VGND sky130_ef_sc_hd__decap_12
XFILLER_0_78_1225 VGND VGND VPWR VPWR sky130_fd_sc_hd__fill_1
XFILLER_0_223_615 VGND VGND VPWR VPWR sky130_fd_sc_hd__fill_1
XFILLER_0_183_15 VPWR VGND VPWR VGND sky130_ef_sc_hd__decap_12
XFILLER_0_218_1147 VGND VGND VPWR VPWR sky130_fd_sc_hd__fill_1
XFILLER_0_190_1339 VGND VGND VPWR VPWR sky130_fd_sc_hd__decap_3
XFILLER_0_210_309 VPWR VGND VPWR VGND sky130_ef_sc_hd__decap_12
XFILLER_0_118_1281 VGND VGND VPWR VPWR sky130_fd_sc_hd__fill_1
XFILLER_0_8_1343 VGND VGND VPWR VPWR sky130_fd_sc_hd__fill_1
XFILLER_0_114_1145 VGND VGND VPWR VPWR sky130_fd_sc_hd__decap_3
XFILLER_0_188_1213 VPWR VGND VPWR VGND sky130_ef_sc_hd__decap_12
XFILLER_0_114_1189 VPWR VGND VPWR VGND sky130_ef_sc_hd__decap_12
XFILLER_0_129_641 VGND VGND VPWR VPWR sky130_fd_sc_hd__decap_4
XFILLER_0_19_617 VPWR VGND VPWR VGND sky130_ef_sc_hd__decap_12
XFILLER_0_4_1229 VPWR VGND VPWR VGND sky130_ef_sc_hd__decap_12
XFILLER_0_15_1253 VGND VGND VPWR VPWR sky130_fd_sc_hd__fill_1
XFILLER_0_132_41 VGND VGND VPWR VPWR sky130_fd_sc_hd__decap_8
XFILLER_0_144_655 VGND VGND VPWR VPWR sky130_fd_sc_hd__decap_4
XFILLER_0_6_533 VPWR VGND VPWR VGND sky130_ef_sc_hd__decap_12
XFILLER_0_42_631 VPWR VGND VPWR VGND sky130_ef_sc_hd__decap_12
XFILLER_0_74_3 VPWR VGND VPWR VGND sky130_ef_sc_hd__decap_12
XFILLER_0_1_293 VPWR VGND VPWR VGND sky130_ef_sc_hd__decap_12
XFILLER_0_22_1213 VPWR VGND VPWR VGND sky130_ef_sc_hd__decap_12
XANTENNA_input2_A act_row0_in[10] VGND VGND VPWR VPWR sky130_fd_sc_hd__diode_2
XFILLER_0_214_637 VGND VGND VPWR VPWR sky130_fd_sc_hd__decap_6
XFILLER_0_213_125 VPWR VGND VPWR VGND sky130_ef_sc_hd__decap_12
XFILLER_0_57_1309 VGND VGND VPWR VPWR sky130_fd_sc_hd__fill_1
XFILLER_0_222_681 VPWR VGND VPWR VGND sky130_ef_sc_hd__decap_12
XFILLER_0_213_169 VPWR VGND VPWR VGND sky130_ef_sc_hd__decap_12
XFILLER_0_132_1201 VPWR VGND VPWR VGND sky130_ef_sc_hd__decap_12
XFILLER_0_210_865 VGND VGND VPWR VPWR sky130_fd_sc_hd__decap_3
XTAP_1248 VGND VPWR sky130_fd_sc_hd__tapvpwrvgnd_1
XTAP_1237 VGND VPWR sky130_fd_sc_hd__tapvpwrvgnd_1
XTAP_1226 VGND VPWR sky130_fd_sc_hd__tapvpwrvgnd_1
XTAP_1259 VGND VPWR sky130_fd_sc_hd__tapvpwrvgnd_1
XFILLER_0_108_825 VPWR VGND VPWR VGND sky130_ef_sc_hd__decap_12
XFILLER_0_135_655 VGND VGND VPWR VPWR sky130_fd_sc_hd__fill_2
XFILLER_0_108_869 VPWR VGND VPWR VGND sky130_ef_sc_hd__decap_12
XFILLER_0_107_335 VGND VGND VPWR VPWR sky130_fd_sc_hd__fill_1
XANTENNA_input58_A psum_col0_in[31] VGND VGND VPWR VPWR sky130_fd_sc_hd__diode_2
XFILLER_0_217_497 VGND VGND VPWR VPWR sky130_fd_sc_hd__decap_6
XFILLER_0_62_27 VGND VGND VPWR VPWR sky130_fd_sc_hd__fill_1
XANTENNA_output214_A net214 VGND VGND VPWR VPWR sky130_fd_sc_hd__diode_2
XFILLER_0_38_1275 VGND VGND VPWR VPWR sky130_fd_sc_hd__decap_6
XFILLER_0_77_1291 VPWR VGND VPWR VGND sky130_ef_sc_hd__decap_12
XFILLER_0_213_1033 VPWR VGND VPWR VGND sky130_ef_sc_hd__decap_12
XTAP_2472 VGND VPWR sky130_fd_sc_hd__tapvpwrvgnd_1
XTAP_2461 VGND VPWR sky130_fd_sc_hd__tapvpwrvgnd_1
XTAP_2450 VGND VPWR sky130_fd_sc_hd__tapvpwrvgnd_1
XFILLER_0_62_49 VGND VGND VPWR VPWR sky130_fd_sc_hd__fill_1
XFILLER_0_213_1077 VPWR VGND VPWR VGND sky130_ef_sc_hd__decap_12
XTAP_2483 VGND VPWR sky130_fd_sc_hd__tapvpwrvgnd_1
XTAP_2494 VGND VPWR sky130_fd_sc_hd__tapvpwrvgnd_1
XTAP_1760 VGND VPWR sky130_fd_sc_hd__tapvpwrvgnd_1
XTAP_1793 VGND VPWR sky130_fd_sc_hd__tapvpwrvgnd_1
XTAP_1782 VGND VPWR sky130_fd_sc_hd__tapvpwrvgnd_1
XTAP_1771 VGND VPWR sky130_fd_sc_hd__tapvpwrvgnd_1
XFILLER_0_126_655 VGND VGND VPWR VPWR sky130_fd_sc_hd__decap_4
XFILLER_0_3_503 VGND VGND VPWR VPWR sky130_fd_sc_hd__fill_1
XFILLER_0_24_631 VPWR VGND VPWR VGND sky130_ef_sc_hd__decap_12
XFILLER_0_148_1263 VPWR VGND VPWR VGND sky130_ef_sc_hd__decap_12
XFILLER_0_109_1225 VGND VGND VPWR VPWR sky130_fd_sc_hd__decap_6
XFILLER_0_141_647 VGND VGND VPWR VPWR sky130_fd_sc_hd__decap_8
XFILLER_0_84_1251 VPWR VGND VPWR VGND sky130_ef_sc_hd__decap_12
XFILLER_0_113_305 VPWR VGND VPWR VGND sky130_ef_sc_hd__decap_12
XFILLER_0_109_1269 VPWR VGND VPWR VGND sky130_ef_sc_hd__decap_12
XFILLER_0_45_1213 VPWR VGND VPWR VGND sky130_ef_sc_hd__decap_12
XFILLER_0_113_349 VPWR VGND VPWR VGND sky130_ef_sc_hd__decap_12
XFILLER_0_224_1173 VPWR VGND VPWR VGND sky130_ef_sc_hd__decap_12
XFILLER_0_87_46 VGND VGND VPWR VPWR sky130_fd_sc_hd__fill_2
XFILLER_0_84_1295 VPWR VGND VPWR VGND sky130_ef_sc_hd__decap_12
XFILLER_0_220_1037 VPWR VGND VPWR VGND sky130_ef_sc_hd__decap_12
XFILLER_0_45_1279 VPWR VGND VPWR VGND sky130_ef_sc_hd__decap_12
XFILLER_0_155_1201 VPWR VGND VPWR VGND sky130_ef_sc_hd__decap_12
Xinput2 act_row0_in[10] VGND VGND VPWR VPWR net2 sky130_fd_sc_hd__clkbuf_4
XFILLER_0_194_1283 VPWR VGND VPWR VGND sky130_ef_sc_hd__decap_12
XFILLER_0_224_979 VGND VGND VPWR VPWR sky130_fd_sc_hd__fill_1
XFILLER_0_56_1331 VGND VGND VPWR VPWR sky130_fd_sc_hd__decap_6
XFILLER_0_211_629 VPWR VGND VPWR VGND sky130_ef_sc_hd__decap_12
XFILLER_0_210_106 VGND VGND VPWR VPWR sky130_fd_sc_hd__decap_6
XFILLER_0_155_1267 VPWR VGND VPWR VGND sky130_ef_sc_hd__decap_12
XFILLER_0_91_1255 VPWR VGND VPWR VGND sky130_ef_sc_hd__decap_12
XFILLER_0_52_1239 VPWR VGND VPWR VGND sky130_ef_sc_hd__decap_12
XPHY_309 VGND VGND VPWR VPWR sky130_fd_sc_hd__decap_3
XFILLER_0_4_1037 VPWR VGND VPWR VGND sky130_ef_sc_hd__decap_12
XFILLER_0_7_853 VPWR VGND VPWR VGND sky130_ef_sc_hd__decap_12
XFILLER_0_127_1303 VGND VGND VPWR VPWR sky130_fd_sc_hd__decap_6
XFILLER_0_105_839 VGND VGND VPWR VPWR sky130_fd_sc_hd__fill_1
XFILLER_0_6_363 VGND VGND VPWR VPWR sky130_fd_sc_hd__fill_1
XFILLER_0_7_897 VPWR VGND VPWR VGND sky130_ef_sc_hd__decap_12
XFILLER_0_104_305 VGND VGND VPWR VPWR sky130_fd_sc_hd__decap_3
XFILLER_0_162_1227 VPWR VGND VPWR VGND sky130_ef_sc_hd__decap_12
XFILLER_0_104_349 VPWR VGND VPWR VGND sky130_ef_sc_hd__decap_12
XFILLER_0_203_1213 VPWR VGND VPWR VGND sky130_ef_sc_hd__decap_12
XFILLER_0_63_1335 VGND VGND VPWR VPWR sky130_fd_sc_hd__decap_8
XFILLER_0_219_729 VPWR VGND VPWR VGND sky130_ef_sc_hd__decap_12
XFILLER_0_24_1319 VPWR VGND VPWR VGND sky130_ef_sc_hd__decap_12
XFILLER_0_203_1279 VPWR VGND VPWR VGND sky130_ef_sc_hd__decap_12
XFILLER_0_214_401 VPWR VGND VPWR VGND sky130_ef_sc_hd__decap_12
XFILLER_0_199_647 VPWR VGND VPWR VGND sky130_ef_sc_hd__decap_12
XFILLER_0_214_445 VPWR VGND VPWR VGND sky130_ef_sc_hd__decap_12
XFILLER_0_173_1323 VPWR VGND VPWR VGND sky130_ef_sc_hd__decap_12
XFILLER_0_214_489 VPWR VGND VPWR VGND sky130_ef_sc_hd__decap_12
XFILLER_0_134_1307 VPWR VGND VPWR VGND sky130_ef_sc_hd__decap_12
XFILLER_0_97_645 VGND VGND VPWR VPWR sky130_fd_sc_hd__fill_1
XANTENNA_input112_A w00[5] VGND VGND VPWR VPWR sky130_fd_sc_hd__diode_2
XFILLER_0_210_1217 VPWR VGND VPWR VGND sky130_ef_sc_hd__decap_12
XFILLER_0_210_673 VPWR VGND VPWR VGND sky130_ef_sc_hd__decap_12
XPHY_810 VGND VGND VPWR VPWR sky130_fd_sc_hd__decap_3
XFILLER_0_70_1339 VGND VGND VPWR VPWR sky130_fd_sc_hd__decap_4
XPHY_832 VGND VGND VPWR VPWR sky130_fd_sc_hd__decap_3
XPHY_821 VGND VGND VPWR VPWR sky130_fd_sc_hd__decap_3
XPHY_854 VGND VGND VPWR VPWR sky130_fd_sc_hd__decap_3
XPHY_843 VGND VGND VPWR VPWR sky130_fd_sc_hd__decap_3
XPHY_876 VGND VGND VPWR VPWR sky130_fd_sc_hd__decap_3
XPHY_865 VGND VGND VPWR VPWR sky130_fd_sc_hd__decap_3
XPHY_887 VGND VGND VPWR VPWR sky130_fd_sc_hd__decap_3
XPHY_898 VGND VGND VPWR VPWR sky130_fd_sc_hd__decap_3
XFILLER_0_68_1213 VPWR VGND VPWR VGND sky130_ef_sc_hd__decap_12
XFILLER_0_108_699 VGND VGND VPWR VPWR sky130_fd_sc_hd__fill_1
XFILLER_0_123_647 VPWR VGND VPWR VGND sky130_ef_sc_hd__decap_12
XFILLER_0_111_809 VPWR VGND VPWR VGND sky130_ef_sc_hd__decap_12
XFILLER_0_221_1313 VPWR VGND VPWR VGND sky130_ef_sc_hd__decap_12
XFILLER_0_21_645 VGND VGND VPWR VPWR sky130_fd_sc_hd__fill_1
XFILLER_0_104_1133 VPWR VGND VPWR VGND sky130_ef_sc_hd__decap_12
XFILLER_0_0_539 VPWR VGND VPWR VGND sky130_ef_sc_hd__decap_12
XFILLER_0_148_29 VPWR VGND VPWR VGND sky130_ef_sc_hd__decap_12
XFILLER_0_178_1201 VPWR VGND VPWR VGND sky130_ef_sc_hd__decap_12
XFILLER_0_57_27 VPWR VGND VPWR VGND sky130_ef_sc_hd__decap_12
XFILLER_0_224_209 VPWR VGND VPWR VGND sky130_ef_sc_hd__decap_12
XFILLER_0_104_1177 VPWR VGND VPWR VGND sky130_ef_sc_hd__decap_12
XFILLER_0_219_1231 VGND VGND VPWR VPWR sky130_fd_sc_hd__fill_1
XFILLER_0_217_261 VPWR VGND VPWR VGND sky130_ef_sc_hd__decap_12
XFILLER_0_180_27 VGND VGND VPWR VPWR sky130_fd_sc_hd__fill_1
XTAP_2280 VGND VPWR sky130_fd_sc_hd__tapvpwrvgnd_1
XFILLER_0_5_1313 VPWR VGND VPWR VGND sky130_ef_sc_hd__decap_12
XFILLER_0_180_49 VGND VGND VPWR VPWR sky130_fd_sc_hd__fill_1
XTAP_2291 VGND VPWR sky130_fd_sc_hd__tapvpwrvgnd_1
XFILLER_0_8_617 VGND VGND VPWR VPWR sky130_fd_sc_hd__fill_1
XFILLER_0_12_1201 VPWR VGND VPWR VGND sky130_ef_sc_hd__decap_12
XFILLER_0_132_3 VPWR VGND VPWR VGND sky130_ef_sc_hd__decap_12
XFILLER_0_22_41 VGND VGND VPWR VPWR sky130_fd_sc_hd__decap_8
XTAP_1590 VGND VPWR sky130_fd_sc_hd__tapvpwrvgnd_1
XFILLER_0_185_1249 VGND VGND VPWR VPWR sky130_fd_sc_hd__decap_4
XFILLER_0_189_25 VPWR VGND VPWR VGND sky130_ef_sc_hd__decap_12
XFILLER_0_113_113 VPWR VGND VPWR VGND sky130_ef_sc_hd__decap_12
XFILLER_0_109_1033 VPWR VGND VPWR VGND sky130_ef_sc_hd__decap_12
XFILLER_0_114_669 VGND VGND VPWR VPWR sky130_fd_sc_hd__decap_3
XFILLER_0_4_867 VGND VGND VPWR VPWR sky130_fd_sc_hd__fill_1
XFILLER_0_109_1077 VPWR VGND VPWR VGND sky130_ef_sc_hd__decap_12
XFILLER_0_37_3 VPWR VGND VPWR VGND sky130_ef_sc_hd__decap_12
XFILLER_0_212_905 VPWR VGND VPWR VGND sky130_ef_sc_hd__decap_12
XFILLER_0_196_617 VGND VGND VPWR VPWR sky130_fd_sc_hd__fill_1
XFILLER_0_212_949 VPWR VGND VPWR VGND sky130_ef_sc_hd__decap_12
XFILLER_0_79_645 VGND VGND VPWR VPWR sky130_fd_sc_hd__fill_1
XPHY_106 VGND VGND VPWR VPWR sky130_fd_sc_hd__decap_3
XFILLER_0_220_993 VPWR VGND VPWR VGND sky130_ef_sc_hd__decap_12
XPHY_139 VGND VGND VPWR VPWR sky130_fd_sc_hd__decap_3
XPHY_117 VGND VGND VPWR VPWR sky130_fd_sc_hd__decap_3
XPHY_128 VGND VGND VPWR VPWR sky130_fd_sc_hd__decap_3
XFILLER_0_104_113 VPWR VGND VPWR VGND sky130_ef_sc_hd__decap_12
XFILLER_0_120_617 VGND VGND VPWR VPWR sky130_fd_sc_hd__fill_1
XFILLER_0_28_1263 VPWR VGND VPWR VGND sky130_ef_sc_hd__decap_12
XFILLER_0_219_559 VGND VGND VPWR VPWR sky130_fd_sc_hd__fill_1
XFILLER_0_98_1239 VPWR VGND VPWR VGND sky130_ef_sc_hd__decap_12
Xoutput191 net191 VGND VGND VPWR VPWR psum_col0_out[4] sky130_fd_sc_hd__clkbuf_4
Xoutput180 net180 VGND VGND VPWR VPWR psum_col0_out[23] sky130_fd_sc_hd__clkbuf_4
XFILLER_0_215_721 VGND VGND VPWR VPWR sky130_fd_sc_hd__decap_6
XFILLER_0_215_765 VPWR VGND VPWR VGND sky130_ef_sc_hd__decap_12
XFILLER_0_187_617 VPWR VGND VPWR VGND sky130_ef_sc_hd__decap_12
XFILLER_0_214_253 VPWR VGND VPWR VGND sky130_ef_sc_hd__decap_12
XFILLER_0_138_1251 VPWR VGND VPWR VGND sky130_ef_sc_hd__decap_12
XFILLER_0_138_1295 VPWR VGND VPWR VGND sky130_ef_sc_hd__decap_12
XFILLER_0_35_1201 VPWR VGND VPWR VGND sky130_ef_sc_hd__decap_12
XFILLER_0_214_1161 VPWR VGND VPWR VGND sky130_ef_sc_hd__decap_12
XPHY_8 VGND VGND VPWR VPWR sky130_fd_sc_hd__decap_3
XFILLER_0_74_1283 VPWR VGND VPWR VGND sky130_ef_sc_hd__decap_12
XFILLER_0_214_53 VPWR VGND VPWR VGND sky130_ef_sc_hd__decap_12
XFILLER_0_210_481 VPWR VGND VPWR VGND sky130_ef_sc_hd__decap_12
XFILLER_0_35_1267 VPWR VGND VPWR VGND sky130_ef_sc_hd__decap_12
XFILLER_0_214_97 VPWR VGND VPWR VGND sky130_ef_sc_hd__decap_12
XPHY_640 VGND VGND VPWR VPWR sky130_fd_sc_hd__decap_3
XANTENNA_u_pe11_weight_in[4] net159 VGND VGND VPWR VPWR sky130_fd_sc_hd__diode_2
XPHY_651 VGND VGND VPWR VPWR sky130_fd_sc_hd__decap_3
XPHY_662 VGND VGND VPWR VPWR sky130_fd_sc_hd__decap_3
XPHY_684 VGND VGND VPWR VPWR sky130_fd_sc_hd__decap_3
XPHY_673 VGND VGND VPWR VPWR sky130_fd_sc_hd__decap_3
XPHY_695 VGND VGND VPWR VPWR sky130_fd_sc_hd__decap_3
XFILLER_0_109_953 VPWR VGND VPWR VGND sky130_ef_sc_hd__decap_12
XFILLER_0_5_609 VGND VGND VPWR VPWR sky130_fd_sc_hd__decap_6
XFILLER_0_145_1255 VPWR VGND VPWR VGND sky130_ef_sc_hd__decap_12
XFILLER_0_106_1217 VPWR VGND VPWR VGND sky130_ef_sc_hd__decap_12
XFILLER_0_111_617 VPWR VGND VPWR VGND sky130_ef_sc_hd__decap_12
XFILLER_0_68_15 VPWR VGND VPWR VGND sky130_ef_sc_hd__decap_12
XFILLER_0_7_29 VPWR VGND VPWR VGND sky130_ef_sc_hd__decap_12
XFILLER_0_159_39 VGND VGND VPWR VPWR sky130_fd_sc_hd__decap_8
XFILLER_0_221_1121 VPWR VGND VPWR VGND sky130_ef_sc_hd__decap_12
XFILLER_0_42_1227 VPWR VGND VPWR VGND sky130_ef_sc_hd__decap_12
XFILLER_0_225_529 VPWR VGND VPWR VGND sky130_ef_sc_hd__decap_12
XFILLER_0_218_581 VGND VGND VPWR VPWR sky130_fd_sc_hd__decap_6
XFILLER_0_108_10 VPWR VGND VPWR VGND sky130_ef_sc_hd__decap_12
XFILLER_0_108_65 VPWR VGND VPWR VGND sky130_ef_sc_hd__decap_12
XFILLER_0_191_1253 VGND VGND VPWR VPWR sky130_fd_sc_hd__fill_1
XFILLER_0_178_617 VGND VGND VPWR VPWR sky130_fd_sc_hd__fill_1
XFILLER_0_191_15 VPWR VGND VPWR VGND sky130_ef_sc_hd__decap_12
XFILLER_0_117_1335 VGND VGND VPWR VPWR sky130_fd_sc_hd__decap_8
XFILLER_0_220_245 VGND VGND VPWR VPWR sky130_fd_sc_hd__decap_6
XFILLER_0_53_1323 VPWR VGND VPWR VGND sky130_ef_sc_hd__decap_12
XFILLER_0_220_289 VPWR VGND VPWR VGND sky130_ef_sc_hd__decap_12
XFILLER_0_5_1121 VPWR VGND VPWR VGND sky130_ef_sc_hd__decap_12
XFILLER_0_14_1307 VPWR VGND VPWR VGND sky130_ef_sc_hd__decap_12
XFILLER_0_91_629 VPWR VGND VPWR VGND sky130_ef_sc_hd__decap_12
XFILLER_0_1_1007 VGND VGND VPWR VPWR sky130_fd_sc_hd__fill_1
XFILLER_0_140_41 VGND VGND VPWR VPWR sky130_fd_sc_hd__decap_8
XFILLER_0_163_1311 VPWR VGND VPWR VGND sky130_ef_sc_hd__decap_12
XFILLER_0_114_433 VPWR VGND VPWR VGND sky130_ef_sc_hd__decap_12
Xinput82 psum_col1_in[24] VGND VGND VPWR VPWR net82 sky130_fd_sc_hd__dlymetal6s2s_1
XFILLER_0_226_1065 VPWR VGND VPWR VGND sky130_ef_sc_hd__decap_12
Xinput71 psum_col1_in[14] VGND VGND VPWR VPWR net71 sky130_fd_sc_hd__buf_1
Xinput60 psum_col0_in[4] VGND VGND VPWR VPWR net60 sky130_fd_sc_hd__buf_1
XFILLER_0_102_617 VGND VGND VPWR VPWR sky130_fd_sc_hd__fill_1
XFILLER_0_114_477 VPWR VGND VPWR VGND sky130_ef_sc_hd__decap_12
Xinput93 psum_col1_in[5] VGND VGND VPWR VPWR net93 sky130_fd_sc_hd__buf_1
XFILLER_0_124_1339 VGND VGND VPWR VPWR sky130_fd_sc_hd__decap_4
XFILLER_0_200_1227 VPWR VGND VPWR VGND sky130_ef_sc_hd__decap_12
XFILLER_0_0_881 VGND VGND VPWR VPWR sky130_fd_sc_hd__fill_2
XFILLER_0_58_1201 VPWR VGND VPWR VGND sky130_ef_sc_hd__decap_12
XFILLER_0_212_713 VPWR VGND VPWR VGND sky130_ef_sc_hd__decap_12
XFILLER_0_212_757 VPWR VGND VPWR VGND sky130_ef_sc_hd__decap_12
XFILLER_0_211_223 VGND VGND VPWR VPWR sky130_fd_sc_hd__fill_1
XFILLER_0_169_617 VPWR VGND VPWR VGND sky130_ef_sc_hd__decap_12
XFILLER_0_170_1337 VGND VGND VPWR VPWR sky130_fd_sc_hd__fill_1
XFILLER_0_211_1301 VPWR VGND VPWR VGND sky130_ef_sc_hd__decap_12
XFILLER_0_192_631 VPWR VGND VPWR VGND sky130_ef_sc_hd__decap_12
XFILLER_0_109_205 VPWR VGND VPWR VGND sky130_ef_sc_hd__decap_12
XFILLER_0_109_249 VPWR VGND VPWR VGND sky130_ef_sc_hd__decap_12
XFILLER_0_106_923 VGND VGND VPWR VPWR sky130_fd_sc_hd__fill_1
XFILLER_0_65_1249 VGND VGND VPWR VPWR sky130_fd_sc_hd__decap_4
XANTENNA_input40_A psum_col0_in[15] VGND VGND VPWR VPWR sky130_fd_sc_hd__diode_2
XFILLER_0_38_29 VPWR VGND VPWR VGND sky130_ef_sc_hd__decap_12
XFILLER_0_175_1237 VPWR VGND VPWR VGND sky130_ef_sc_hd__decap_12
XFILLER_0_215_573 VPWR VGND VPWR VGND sky130_ef_sc_hd__decap_12
XFILLER_0_70_49 VGND VGND VPWR VPWR sky130_fd_sc_hd__fill_1
XFILLER_0_73_629 VPWR VGND VPWR VGND sky130_ef_sc_hd__decap_12
XPHY_470 VGND VGND VPWR VPWR sky130_fd_sc_hd__decap_3
XFILLER_0_109_783 VGND VGND VPWR VPWR sky130_fd_sc_hd__fill_1
XFILLER_0_5_417 VPWR VGND VPWR VGND sky130_ef_sc_hd__decap_12
XPHY_492 VGND VGND VPWR VPWR sky130_fd_sc_hd__decap_3
XPHY_481 VGND VGND VPWR VPWR sky130_fd_sc_hd__decap_3
XANTENNA_u_pe01_psum_in[20] net78 VGND VGND VPWR VPWR sky130_fd_sc_hd__diode_2
XPHY_1080 VGND VGND VPWR VPWR sky130_fd_sc_hd__decap_3
XPHY_1091 VGND VGND VPWR VPWR sky130_fd_sc_hd__decap_3
XFILLER_0_79_47 VGND VGND VPWR VPWR sky130_fd_sc_hd__decap_3
XFILLER_0_112_937 VPWR VGND VPWR VGND sky130_ef_sc_hd__decap_12
XFILLER_0_110_77 VGND VGND VPWR VPWR sky130_fd_sc_hd__decap_6
XFILLER_0_186_15 VPWR VGND VPWR VGND sky130_ef_sc_hd__decap_12
XFILLER_0_111_447 VGND VGND VPWR VPWR sky130_fd_sc_hd__fill_1
XFILLER_0_0_177 VGND VGND VPWR VPWR sky130_fd_sc_hd__fill_2
XFILLER_0_0_155 VGND VGND VPWR VPWR sky130_fd_sc_hd__fill_2
XFILLER_0_225_337 VPWR VGND VPWR VGND sky130_ef_sc_hd__decap_12
XFILLER_0_217_1009 VPWR VGND VPWR VGND sky130_ef_sc_hd__decap_12
XFILLER_0_7_1205 VPWR VGND VPWR VGND sky130_ef_sc_hd__decap_12
XFILLER_0_113_1007 VGND VGND VPWR VPWR sky130_fd_sc_hd__fill_1
XFILLER_0_18_1251 VPWR VGND VPWR VGND sky130_ef_sc_hd__decap_12
XFILLER_0_174_631 VPWR VGND VPWR VGND sky130_ef_sc_hd__decap_12
XFILLER_0_18_1295 VPWR VGND VPWR VGND sky130_ef_sc_hd__decap_12
XFILLER_0_130_1343 VGND VGND VPWR VPWR sky130_fd_sc_hd__fill_1
XFILLER_0_88_1227 VPWR VGND VPWR VGND sky130_ef_sc_hd__decap_12
XFILLER_0_107_709 VPWR VGND VPWR VGND sky130_ef_sc_hd__decap_12
XFILLER_0_5_951 VGND VGND VPWR VPWR sky130_fd_sc_hd__fill_1
XFILLER_0_128_1283 VPWR VGND VPWR VGND sky130_ef_sc_hd__decap_12
XFILLER_0_99_1323 VPWR VGND VPWR VGND sky130_ef_sc_hd__decap_12
XFILLER_0_25_1255 VPWR VGND VPWR VGND sky130_ef_sc_hd__decap_12
XTAP_2802 VGND VPWR sky130_fd_sc_hd__tapvpwrvgnd_1
XTAP_2824 VGND VPWR sky130_fd_sc_hd__tapvpwrvgnd_1
XTAP_2846 VGND VPWR sky130_fd_sc_hd__tapvpwrvgnd_1
XTAP_2813 VGND VPWR sky130_fd_sc_hd__tapvpwrvgnd_1
XTAP_2835 VGND VPWR sky130_fd_sc_hd__tapvpwrvgnd_1
XFILLER_0_174_1281 VGND VGND VPWR VPWR sky130_fd_sc_hd__fill_1
XTAP_2868 VGND VPWR sky130_fd_sc_hd__tapvpwrvgnd_1
XFILLER_0_212_587 VGND VGND VPWR VPWR sky130_fd_sc_hd__fill_1
XTAP_2879 VGND VPWR sky130_fd_sc_hd__tapvpwrvgnd_1
XTAP_2857 VGND VPWR sky130_fd_sc_hd__tapvpwrvgnd_1
XFILLER_0_71_1253 VGND VGND VPWR VPWR sky130_fd_sc_hd__fill_1
XFILLER_0_211_1175 VGND VGND VPWR VPWR sky130_fd_sc_hd__fill_1
XFILLER_0_55_629 VPWR VGND VPWR VGND sky130_ef_sc_hd__decap_12
XANTENNA_input88_A psum_col1_in[2] VGND VGND VPWR VPWR sky130_fd_sc_hd__diode_2
XFILLER_0_107_1301 VPWR VGND VPWR VGND sky130_ef_sc_hd__decap_12
XFILLER_0_142_1225 VGND VGND VPWR VPWR sky130_fd_sc_hd__fill_1
XFILLER_0_43_1311 VPWR VGND VPWR VGND sky130_ef_sc_hd__decap_12
XFILLER_0_65_27 VPWR VGND VPWR VGND sky130_ef_sc_hd__decap_12
XFILLER_0_156_29 VPWR VGND VPWR VGND sky130_ef_sc_hd__decap_12
XFILLER_0_218_1329 VPWR VGND VPWR VGND sky130_ef_sc_hd__decap_12
XFILLER_0_222_307 VGND VGND VPWR VPWR sky130_fd_sc_hd__fill_1
XFILLER_0_216_893 VPWR VGND VPWR VGND sky130_ef_sc_hd__decap_12
XFILLER_0_164_6 VGND VGND VPWR VPWR sky130_fd_sc_hd__fill_2
XFILLER_0_153_1343 VGND VGND VPWR VPWR sky130_fd_sc_hd__fill_1
XFILLER_0_81_15 VPWR VGND VPWR VGND sky130_ef_sc_hd__decap_12
XFILLER_0_105_22 VPWR VGND VPWR VGND sky130_ef_sc_hd__decap_12
XFILLER_0_156_631 VPWR VGND VPWR VGND sky130_ef_sc_hd__decap_12
XFILLER_0_50_1337 VGND VGND VPWR VPWR sky130_fd_sc_hd__fill_1
XFILLER_0_212_3 VPWR VGND VPWR VGND sky130_ef_sc_hd__decap_12
XFILLER_0_112_1073 VPWR VGND VPWR VGND sky130_ef_sc_hd__decap_12
XFILLER_0_171_645 VGND VGND VPWR VPWR sky130_fd_sc_hd__fill_1
XFILLER_0_30_41 VGND VGND VPWR VPWR sky130_fd_sc_hd__decap_8
XFILLER_0_5_225 VPWR VGND VPWR VGND sky130_ef_sc_hd__decap_12
XFILLER_0_6_737 VPWR VGND VPWR VGND sky130_ef_sc_hd__decap_12
XFILLER_0_112_701 VPWR VGND VPWR VGND sky130_ef_sc_hd__decap_12
XFILLER_0_223_1057 VGND VGND VPWR VPWR sky130_fd_sc_hd__decap_6
XFILLER_0_197_47 VGND VGND VPWR VPWR sky130_fd_sc_hd__fill_1
XFILLER_0_201_1311 VPWR VGND VPWR VGND sky130_ef_sc_hd__decap_12
XFILLER_0_121_1309 VGND VGND VPWR VPWR sky130_fd_sc_hd__fill_1
XFILLER_0_1_497 VGND VGND VPWR VPWR sky130_fd_sc_hd__decap_6
XFILLER_0_226_657 VGND VGND VPWR VPWR sky130_fd_sc_hd__decap_4
XFILLER_0_225_167 VGND VGND VPWR VPWR sky130_fd_sc_hd__fill_1
XFILLER_0_213_329 VGND VGND VPWR VPWR sky130_fd_sc_hd__decap_6
XFILLER_0_119_1249 VGND VGND VPWR VPWR sky130_fd_sc_hd__decap_4
XFILLER_0_94_1275 VGND VGND VPWR VPWR sky130_fd_sc_hd__decap_6
XFILLER_0_55_1237 VPWR VGND VPWR VGND sky130_ef_sc_hd__decap_12
XTAP_2109 VGND VPWR sky130_fd_sc_hd__tapvpwrvgnd_1
XFILLER_0_221_373 VPWR VGND VPWR VGND sky130_ef_sc_hd__decap_12
XTAP_1419 VGND VPWR sky130_fd_sc_hd__tapvpwrvgnd_1
XTAP_1408 VGND VPWR sky130_fd_sc_hd__tapvpwrvgnd_1
XFILLER_0_37_629 VPWR VGND VPWR VGND sky130_ef_sc_hd__decap_12
XFILLER_0_107_517 VPWR VGND VPWR VGND sky130_ef_sc_hd__decap_12
XFILLER_0_165_1225 VPWR VGND VPWR VGND sky130_ef_sc_hd__decap_12
XFILLER_0_60_643 VPWR VGND VPWR VGND sky130_ef_sc_hd__decap_12
XFILLER_0_141_1291 VPWR VGND VPWR VGND sky130_ef_sc_hd__decap_12
XFILLER_0_176_1343 VGND VGND VPWR VPWR sky130_fd_sc_hd__fill_1
XANTENNA_input142_A w10[3] VGND VGND VPWR VPWR sky130_fd_sc_hd__diode_2
XFILLER_0_102_1275 VGND VGND VPWR VPWR sky130_fd_sc_hd__decap_6
XFILLER_0_216_189 VGND VGND VPWR VPWR sky130_fd_sc_hd__decap_6
XTAP_2610 VGND VPWR sky130_fd_sc_hd__tapvpwrvgnd_1
XFILLER_0_213_841 VPWR VGND VPWR VGND sky130_ef_sc_hd__decap_12
XTAP_2621 VGND VPWR sky130_fd_sc_hd__tapvpwrvgnd_1
XTAP_2632 VGND VPWR sky130_fd_sc_hd__tapvpwrvgnd_1
XTAP_2654 VGND VPWR sky130_fd_sc_hd__tapvpwrvgnd_1
XTAP_2643 VGND VPWR sky130_fd_sc_hd__tapvpwrvgnd_1
XTAP_2676 VGND VPWR sky130_fd_sc_hd__tapvpwrvgnd_1
XTAP_2665 VGND VPWR sky130_fd_sc_hd__tapvpwrvgnd_1
XTAP_2687 VGND VPWR sky130_fd_sc_hd__tapvpwrvgnd_1
XTAP_1920 VGND VPWR sky130_fd_sc_hd__tapvpwrvgnd_1
XTAP_1942 VGND VPWR sky130_fd_sc_hd__tapvpwrvgnd_1
XTAP_1931 VGND VPWR sky130_fd_sc_hd__tapvpwrvgnd_1
XTAP_2698 VGND VPWR sky130_fd_sc_hd__tapvpwrvgnd_1
XTAP_1953 VGND VPWR sky130_fd_sc_hd__tapvpwrvgnd_1
XTAP_1975 VGND VPWR sky130_fd_sc_hd__tapvpwrvgnd_1
XFILLER_0_138_631 VPWR VGND VPWR VGND sky130_ef_sc_hd__decap_12
XTAP_1986 VGND VPWR sky130_fd_sc_hd__tapvpwrvgnd_1
XTAP_1964 VGND VPWR sky130_fd_sc_hd__tapvpwrvgnd_1
XFILLER_0_222_53 VPWR VGND VPWR VGND sky130_ef_sc_hd__decap_12
XTAP_1997 VGND VPWR sky130_fd_sc_hd__tapvpwrvgnd_1
XFILLER_0_183_1303 VGND VGND VPWR VPWR sky130_fd_sc_hd__decap_6
XFILLER_0_222_97 VPWR VGND VPWR VGND sky130_ef_sc_hd__decap_12
XFILLER_0_153_645 VGND VGND VPWR VPWR sky130_fd_sc_hd__fill_1
XFILLER_0_3_729 VPWR VGND VPWR VGND sky130_ef_sc_hd__decap_12
XFILLER_0_80_1319 VPWR VGND VPWR VGND sky130_ef_sc_hd__decap_12
XFILLER_0_107_1175 VGND VGND VPWR VPWR sky130_fd_sc_hd__fill_1
XFILLER_0_76_15 VPWR VGND VPWR VGND sky130_ef_sc_hd__decap_12
XFILLER_0_167_39 VGND VGND VPWR VPWR sky130_fd_sc_hd__decap_8
XFILLER_0_120_1331 VGND VGND VPWR VPWR sky130_fd_sc_hd__decap_6
XFILLER_0_190_1307 VPWR VGND VPWR VGND sky130_ef_sc_hd__decap_12
XFILLER_0_183_27 VPWR VGND VPWR VGND sky130_ef_sc_hd__decap_12
XFILLER_0_162_3 VPWR VGND VPWR VGND sky130_ef_sc_hd__decap_12
XFILLER_0_188_1225 VGND VGND VPWR VPWR sky130_fd_sc_hd__fill_1
XFILLER_0_89_1311 VPWR VGND VPWR VGND sky130_ef_sc_hd__decap_12
XFILLER_0_19_629 VPWR VGND VPWR VGND sky130_ef_sc_hd__decap_12
XFILLER_0_54_1281 VGND VGND VPWR VPWR sky130_fd_sc_hd__fill_1
XFILLER_0_6_501 VPWR VGND VPWR VGND sky130_ef_sc_hd__decap_12
XFILLER_0_6_545 VPWR VGND VPWR VGND sky130_ef_sc_hd__decap_12
XFILLER_0_225_1119 VGND VGND VPWR VPWR sky130_fd_sc_hd__fill_1
XFILLER_0_6_589 VPWR VGND VPWR VGND sky130_ef_sc_hd__decap_12
XFILLER_0_42_643 VPWR VGND VPWR VGND sky130_ef_sc_hd__decap_12
XFILLER_0_112_531 VGND VGND VPWR VPWR sky130_fd_sc_hd__fill_1
XFILLER_0_125_1253 VGND VGND VPWR VPWR sky130_fd_sc_hd__fill_1
XFILLER_0_67_3 VPWR VGND VPWR VGND sky130_ef_sc_hd__decap_12
XFILLER_0_1_261 VPWR VGND VPWR VGND sky130_ef_sc_hd__decap_12
XFILLER_0_199_1343 VGND VGND VPWR VPWR sky130_fd_sc_hd__fill_1
XFILLER_0_22_1225 VGND VGND VPWR VPWR sky130_fd_sc_hd__fill_1
XFILLER_0_5_51 VGND VGND VPWR VPWR sky130_fd_sc_hd__decap_4
XFILLER_0_96_1337 VGND VGND VPWR VPWR sky130_fd_sc_hd__fill_1
XFILLER_0_213_137 VPWR VGND VPWR VGND sky130_ef_sc_hd__decap_12
XFILLER_0_222_693 VGND VGND VPWR VPWR sky130_fd_sc_hd__decap_6
XFILLER_0_221_181 VPWR VGND VPWR VGND sky130_ef_sc_hd__decap_12
XFILLER_0_132_1213 VPWR VGND VPWR VGND sky130_ef_sc_hd__decap_12
XTAP_1238 VGND VPWR sky130_fd_sc_hd__tapvpwrvgnd_1
XTAP_1227 VGND VPWR sky130_fd_sc_hd__tapvpwrvgnd_1
XFILLER_0_210_877 VGND VGND VPWR VPWR sky130_fd_sc_hd__fill_1
XTAP_1249 VGND VPWR sky130_fd_sc_hd__tapvpwrvgnd_1
XFILLER_0_33_1343 VGND VGND VPWR VPWR sky130_fd_sc_hd__fill_1
XFILLER_0_167_1309 VGND VGND VPWR VPWR sky130_fd_sc_hd__fill_1
XFILLER_0_135_645 VGND VGND VPWR VPWR sky130_fd_sc_hd__fill_1
XFILLER_0_108_837 VPWR VGND VPWR VGND sky130_ef_sc_hd__decap_12
XFILLER_0_208_1339 VGND VGND VPWR VPWR sky130_fd_sc_hd__decap_3
XFILLER_0_205_605 VPWR VGND VPWR VGND sky130_ef_sc_hd__decap_12
XFILLER_0_46_29 VPWR VGND VPWR VGND sky130_ef_sc_hd__decap_12
XFILLER_0_213_1001 VGND VGND VPWR VPWR sky130_fd_sc_hd__decap_6
XFILLER_0_213_671 VGND VGND VPWR VPWR sky130_fd_sc_hd__fill_1
XFILLER_0_213_1045 VPWR VGND VPWR VGND sky130_ef_sc_hd__decap_12
XTAP_2451 VGND VPWR sky130_fd_sc_hd__tapvpwrvgnd_1
XTAP_2440 VGND VPWR sky130_fd_sc_hd__tapvpwrvgnd_1
XTAP_2462 VGND VPWR sky130_fd_sc_hd__tapvpwrvgnd_1
XANTENNA_output207_A net207 VGND VGND VPWR VPWR sky130_fd_sc_hd__diode_2
XTAP_2495 VGND VPWR sky130_fd_sc_hd__tapvpwrvgnd_1
XTAP_2484 VGND VPWR sky130_fd_sc_hd__tapvpwrvgnd_1
XTAP_2473 VGND VPWR sky130_fd_sc_hd__tapvpwrvgnd_1
XTAP_1750 VGND VPWR sky130_fd_sc_hd__tapvpwrvgnd_1
XTAP_1761 VGND VPWR sky130_fd_sc_hd__tapvpwrvgnd_1
XFILLER_0_213_1089 VPWR VGND VPWR VGND sky130_ef_sc_hd__decap_12
XTAP_1783 VGND VPWR sky130_fd_sc_hd__tapvpwrvgnd_1
XTAP_1794 VGND VPWR sky130_fd_sc_hd__tapvpwrvgnd_1
XFILLER_0_7_309 VPWR VGND VPWR VGND sky130_ef_sc_hd__decap_12
XTAP_1772 VGND VPWR sky130_fd_sc_hd__tapvpwrvgnd_1
XFILLER_0_187_1291 VPWR VGND VPWR VGND sky130_ef_sc_hd__decap_12
XFILLER_0_148_1275 VGND VGND VPWR VPWR sky130_fd_sc_hd__decap_6
XFILLER_0_24_643 VPWR VGND VPWR VGND sky130_ef_sc_hd__decap_12
XFILLER_0_113_317 VPWR VGND VPWR VGND sky130_ef_sc_hd__decap_12
XFILLER_0_3_559 VGND VGND VPWR VPWR sky130_fd_sc_hd__fill_1
XFILLER_0_45_1225 VPWR VGND VPWR VGND sky130_ef_sc_hd__decap_12
XFILLER_0_84_1263 VPWR VGND VPWR VGND sky130_ef_sc_hd__decap_12
XFILLER_0_224_1141 VGND VGND VPWR VPWR sky130_fd_sc_hd__decap_6
XFILLER_0_220_1005 VPWR VGND VPWR VGND sky130_ef_sc_hd__decap_12
XFILLER_0_178_49 VGND VGND VPWR VPWR sky130_fd_sc_hd__fill_1
XFILLER_0_224_1185 VPWR VGND VPWR VGND sky130_ef_sc_hd__decap_12
XFILLER_0_220_1049 VPWR VGND VPWR VGND sky130_ef_sc_hd__decap_12
XFILLER_0_194_15 VPWR VGND VPWR VGND sky130_ef_sc_hd__decap_12
XFILLER_0_194_1251 VPWR VGND VPWR VGND sky130_ef_sc_hd__decap_12
XFILLER_0_224_925 VPWR VGND VPWR VGND sky130_ef_sc_hd__decap_12
XFILLER_0_155_1213 VPWR VGND VPWR VGND sky130_ef_sc_hd__decap_12
XFILLER_0_194_1295 VPWR VGND VPWR VGND sky130_ef_sc_hd__decap_12
XFILLER_0_91_1201 VPWR VGND VPWR VGND sky130_ef_sc_hd__decap_12
Xinput3 act_row0_in[11] VGND VGND VPWR VPWR net3 sky130_fd_sc_hd__clkbuf_4
XFILLER_0_21_1291 VPWR VGND VPWR VGND sky130_ef_sc_hd__decap_12
XFILLER_0_155_1279 VPWR VGND VPWR VGND sky130_ef_sc_hd__decap_12
XFILLER_0_56_1343 VGND VGND VPWR VPWR sky130_fd_sc_hd__fill_1
XFILLER_0_91_1267 VPWR VGND VPWR VGND sky130_ef_sc_hd__decap_12
XFILLER_0_4_1005 VPWR VGND VPWR VGND sky130_ef_sc_hd__decap_12
XFILLER_0_4_1049 VPWR VGND VPWR VGND sky130_ef_sc_hd__decap_12
XFILLER_0_117_645 VGND VGND VPWR VPWR sky130_fd_sc_hd__fill_1
XFILLER_0_166_1331 VGND VGND VPWR VPWR sky130_fd_sc_hd__decap_6
XFILLER_0_7_865 VGND VGND VPWR VPWR sky130_fd_sc_hd__decap_3
XFILLER_0_162_1239 VPWR VGND VPWR VGND sky130_ef_sc_hd__decap_12
XFILLER_0_63_1303 VGND VGND VPWR VPWR sky130_fd_sc_hd__decap_6
XFILLER_0_203_1225 VPWR VGND VPWR VGND sky130_ef_sc_hd__decap_12
XANTENNA_u_pe01_weight_in[15] net123 VGND VGND VPWR VPWR sky130_fd_sc_hd__diode_2
XFILLER_0_113_895 VGND VGND VPWR VPWR sky130_fd_sc_hd__fill_1
XFILLER_0_2_581 VGND VGND VPWR VPWR sky130_fd_sc_hd__decap_6
XFILLER_0_226_240 VGND VGND VPWR VPWR sky130_fd_sc_hd__decap_3
XFILLER_0_214_413 VGND VGND VPWR VPWR sky130_fd_sc_hd__decap_6
XFILLER_0_214_457 VPWR VGND VPWR VGND sky130_ef_sc_hd__decap_12
XFILLER_0_173_1335 VGND VGND VPWR VPWR sky130_fd_sc_hd__fill_1
XFILLER_0_202_619 VPWR VGND VPWR VGND sky130_ef_sc_hd__decap_12
XFILLER_0_134_1319 VPWR VGND VPWR VGND sky130_ef_sc_hd__decap_12
XFILLER_0_70_1307 VPWR VGND VPWR VGND sky130_ef_sc_hd__decap_12
XFILLER_0_210_641 VGND VGND VPWR VPWR sky130_fd_sc_hd__decap_3
XPHY_811 VGND VGND VPWR VPWR sky130_fd_sc_hd__decap_3
XPHY_800 VGND VGND VPWR VPWR sky130_fd_sc_hd__decap_3
XANTENNA_input105_A w00[13] VGND VGND VPWR VPWR sky130_fd_sc_hd__diode_2
XFILLER_0_210_1229 VGND VGND VPWR VPWR sky130_fd_sc_hd__decap_3
XFILLER_0_210_685 VPWR VGND VPWR VGND sky130_ef_sc_hd__decap_12
XPHY_822 VGND VGND VPWR VPWR sky130_fd_sc_hd__decap_3
XPHY_844 VGND VGND VPWR VPWR sky130_fd_sc_hd__decap_3
XPHY_833 VGND VGND VPWR VPWR sky130_fd_sc_hd__decap_3
XFILLER_0_108_601 VPWR VGND VPWR VGND sky130_ef_sc_hd__decap_12
XPHY_888 VGND VGND VPWR VPWR sky130_fd_sc_hd__decap_3
XPHY_877 VGND VGND VPWR VPWR sky130_fd_sc_hd__decap_3
XFILLER_0_110_1341 VGND VGND VPWR VPWR sky130_fd_sc_hd__decap_3
XFILLER_0_107_111 VGND VGND VPWR VPWR sky130_fd_sc_hd__fill_1
XPHY_855 VGND VGND VPWR VPWR sky130_fd_sc_hd__decap_3
XPHY_866 VGND VGND VPWR VPWR sky130_fd_sc_hd__decap_3
XPHY_899 VGND VGND VPWR VPWR sky130_fd_sc_hd__decap_3
XFILLER_0_108_645 VPWR VGND VPWR VGND sky130_ef_sc_hd__decap_12
XFILLER_0_68_1225 VGND VGND VPWR VPWR sky130_fd_sc_hd__fill_1
XFILLER_0_180_1339 VGND VGND VPWR VPWR sky130_fd_sc_hd__decap_4
XANTENNA_input70_A psum_col1_in[13] VGND VGND VPWR VPWR sky130_fd_sc_hd__diode_2
XFILLER_0_110_309 VPWR VGND VPWR VGND sky130_ef_sc_hd__decap_12
XFILLER_0_221_1325 VGND VGND VPWR VPWR sky130_fd_sc_hd__decap_8
XFILLER_0_178_1213 VPWR VGND VPWR VGND sky130_ef_sc_hd__decap_12
XFILLER_0_196_9 VGND VGND VPWR VPWR sky130_fd_sc_hd__fill_2
XFILLER_0_104_1145 VGND VGND VPWR VPWR sky130_fd_sc_hd__decap_3
XFILLER_0_57_39 VGND VGND VPWR VPWR sky130_fd_sc_hd__decap_8
XFILLER_0_104_1189 VPWR VGND VPWR VGND sky130_ef_sc_hd__decap_12
XFILLER_0_217_273 VGND VGND VPWR VPWR sky130_fd_sc_hd__decap_6
XFILLER_0_79_1343 VGND VGND VPWR VPWR sky130_fd_sc_hd__fill_1
XFILLER_0_164_29 VPWR VGND VPWR VGND sky130_ef_sc_hd__decap_12
XFILLER_0_219_1287 VGND VGND VPWR VPWR sky130_fd_sc_hd__fill_1
XFILLER_0_201_641 VGND VGND VPWR VPWR sky130_fd_sc_hd__decap_4
XTAP_2270 VGND VPWR sky130_fd_sc_hd__tapvpwrvgnd_1
XFILLER_0_5_1325 VPWR VGND VPWR VGND sky130_ef_sc_hd__decap_12
XTAP_2292 VGND VPWR sky130_fd_sc_hd__tapvpwrvgnd_1
XTAP_2281 VGND VPWR sky130_fd_sc_hd__tapvpwrvgnd_1
XFILLER_0_12_1213 VPWR VGND VPWR VGND sky130_ef_sc_hd__decap_12
XTAP_1580 VGND VPWR sky130_fd_sc_hd__tapvpwrvgnd_1
XTAP_1591 VGND VPWR sky130_fd_sc_hd__tapvpwrvgnd_1
XFILLER_0_113_55 VGND VGND VPWR VPWR sky130_fd_sc_hd__fill_1
XFILLER_0_125_3 VPWR VGND VPWR VGND sky130_ef_sc_hd__decap_12
XFILLER_0_189_37 VGND VGND VPWR VPWR sky130_fd_sc_hd__decap_8
XFILLER_0_109_1001 VGND VGND VPWR VPWR sky130_fd_sc_hd__decap_6
XFILLER_0_4_813 VPWR VGND VPWR VGND sky130_ef_sc_hd__decap_12
XFILLER_0_47_1309 VGND VGND VPWR VPWR sky130_fd_sc_hd__fill_1
XFILLER_0_226_1247 VGND VGND VPWR VPWR sky130_fd_sc_hd__decap_8
XFILLER_0_109_1045 VPWR VGND VPWR VGND sky130_ef_sc_hd__decap_12
XFILLER_0_113_125 VPWR VGND VPWR VGND sky130_ef_sc_hd__decap_12
XFILLER_0_113_169 VPWR VGND VPWR VGND sky130_ef_sc_hd__decap_12
XFILLER_0_122_1201 VPWR VGND VPWR VGND sky130_ef_sc_hd__decap_12
XFILLER_0_109_1089 VPWR VGND VPWR VGND sky130_ef_sc_hd__decap_12
XFILLER_0_138_41 VGND VGND VPWR VPWR sky130_fd_sc_hd__decap_8
XFILLER_0_224_755 VGND VGND VPWR VPWR sky130_fd_sc_hd__fill_1
XFILLER_0_212_917 VGND VGND VPWR VPWR sky130_fd_sc_hd__decap_6
XFILLER_0_211_405 VPWR VGND VPWR VGND sky130_ef_sc_hd__decap_12
XFILLER_0_2_41 VPWR VGND VPWR VGND sky130_ef_sc_hd__decap_12
XFILLER_0_211_449 VPWR VGND VPWR VGND sky130_ef_sc_hd__decap_12
XFILLER_0_2_85 VPWR VGND VPWR VGND sky130_ef_sc_hd__decap_12
XFILLER_0_220_961 VPWR VGND VPWR VGND sky130_ef_sc_hd__decap_12
XFILLER_0_94_605 VPWR VGND VPWR VGND sky130_ef_sc_hd__decap_12
XPHY_107 VGND VGND VPWR VPWR sky130_fd_sc_hd__decap_3
XPHY_118 VGND VGND VPWR VPWR sky130_fd_sc_hd__decap_3
XPHY_129 VGND VGND VPWR VPWR sky130_fd_sc_hd__decap_3
XFILLER_0_105_615 VGND VGND VPWR VPWR sky130_fd_sc_hd__fill_1
XFILLER_0_7_673 VPWR VGND VPWR VGND sky130_ef_sc_hd__decap_12
XFILLER_0_104_125 VPWR VGND VPWR VGND sky130_ef_sc_hd__decap_12
XFILLER_0_205_1309 VGND VGND VPWR VPWR sky130_fd_sc_hd__fill_1
XFILLER_0_67_1291 VPWR VGND VPWR VGND sky130_ef_sc_hd__decap_12
XFILLER_0_104_169 VPWR VGND VPWR VGND sky130_ef_sc_hd__decap_12
XFILLER_0_219_505 VPWR VGND VPWR VGND sky130_ef_sc_hd__decap_12
XFILLER_0_28_1275 VGND VGND VPWR VPWR sky130_fd_sc_hd__decap_6
Xoutput170 net170 VGND VGND VPWR VPWR psum_col0_out[14] sky130_fd_sc_hd__clkbuf_4
Xoutput181 net181 VGND VGND VPWR VPWR psum_col0_out[24] sky130_fd_sc_hd__clkbuf_4
Xoutput192 net192 VGND VGND VPWR VPWR psum_col0_out[5] sky130_fd_sc_hd__clkbuf_4
XFILLER_0_214_221 VPWR VGND VPWR VGND sky130_ef_sc_hd__decap_12
XFILLER_0_215_777 VGND VGND VPWR VPWR sky130_fd_sc_hd__decap_6
XFILLER_0_214_265 VPWR VGND VPWR VGND sky130_ef_sc_hd__decap_12
XFILLER_0_138_1263 VPWR VGND VPWR VGND sky130_ef_sc_hd__decap_12
XFILLER_0_187_629 VPWR VGND VPWR VGND sky130_ef_sc_hd__decap_12
XFILLER_0_35_1213 VPWR VGND VPWR VGND sky130_ef_sc_hd__decap_12
XFILLER_0_74_1251 VPWR VGND VPWR VGND sky130_ef_sc_hd__decap_12
XFILLER_0_85_605 VPWR VGND VPWR VGND sky130_ef_sc_hd__decap_12
XPHY_9 VGND VGND VPWR VPWR sky130_fd_sc_hd__decap_3
XFILLER_0_74_1295 VPWR VGND VPWR VGND sky130_ef_sc_hd__decap_12
XFILLER_0_214_1173 VPWR VGND VPWR VGND sky130_ef_sc_hd__decap_12
XFILLER_0_210_1015 VPWR VGND VPWR VGND sky130_ef_sc_hd__decap_12
XFILLER_0_214_65 VPWR VGND VPWR VGND sky130_ef_sc_hd__decap_12
XANTENNA_u_pe11_weight_in[3] net158 VGND VGND VPWR VPWR sky130_fd_sc_hd__diode_2
XFILLER_0_35_1279 VPWR VGND VPWR VGND sky130_ef_sc_hd__decap_12
XFILLER_0_210_1037 VGND VGND VPWR VPWR sky130_fd_sc_hd__decap_6
XFILLER_0_210_493 VGND VGND VPWR VPWR sky130_fd_sc_hd__fill_1
XPHY_630 VGND VGND VPWR VPWR sky130_fd_sc_hd__decap_3
XPHY_652 VGND VGND VPWR VPWR sky130_fd_sc_hd__decap_3
XPHY_641 VGND VGND VPWR VPWR sky130_fd_sc_hd__decap_3
XFILLER_0_109_921 VPWR VGND VPWR VGND sky130_ef_sc_hd__decap_12
XPHY_696 VGND VGND VPWR VPWR sky130_fd_sc_hd__decap_3
XPHY_685 VGND VGND VPWR VPWR sky130_fd_sc_hd__decap_3
XFILLER_0_109_965 VPWR VGND VPWR VGND sky130_ef_sc_hd__decap_12
XPHY_663 VGND VGND VPWR VPWR sky130_fd_sc_hd__decap_3
XPHY_674 VGND VGND VPWR VPWR sky130_fd_sc_hd__decap_3
XFILLER_0_4_109 VPWR VGND VPWR VGND sky130_ef_sc_hd__decap_12
XFILLER_0_0_1233 VGND VGND VPWR VPWR sky130_fd_sc_hd__fill_2
XFILLER_0_108_475 VGND VGND VPWR VPWR sky130_fd_sc_hd__fill_1
XFILLER_0_145_1201 VPWR VGND VPWR VGND sky130_ef_sc_hd__decap_12
XFILLER_0_184_1283 VPWR VGND VPWR VGND sky130_ef_sc_hd__decap_12
XFILLER_0_145_1267 VPWR VGND VPWR VGND sky130_ef_sc_hd__decap_12
XFILLER_0_46_1331 VGND VGND VPWR VPWR sky130_fd_sc_hd__decap_6
XFILLER_0_106_1229 VPWR VGND VPWR VGND sky130_ef_sc_hd__decap_12
XFILLER_0_111_629 VPWR VGND VPWR VGND sky130_ef_sc_hd__decap_12
XFILLER_0_68_49 VGND VGND VPWR VPWR sky130_fd_sc_hd__fill_1
XFILLER_0_68_27 VGND VGND VPWR VPWR sky130_fd_sc_hd__fill_1
XFILLER_0_81_1255 VPWR VGND VPWR VGND sky130_ef_sc_hd__decap_12
XFILLER_0_221_1133 VPWR VGND VPWR VGND sky130_ef_sc_hd__decap_12
XFILLER_0_42_1239 VPWR VGND VPWR VGND sky130_ef_sc_hd__decap_12
XFILLER_0_110_139 VGND VGND VPWR VPWR sky130_fd_sc_hd__fill_1
XFILLER_0_221_1177 VPWR VGND VPWR VGND sky130_ef_sc_hd__decap_12
XFILLER_0_108_22 VGND VGND VPWR VPWR sky130_fd_sc_hd__decap_6
XFILLER_0_117_1303 VGND VGND VPWR VPWR sky130_fd_sc_hd__decap_6
XFILLER_0_108_77 VGND VGND VPWR VPWR sky130_fd_sc_hd__decap_6
XFILLER_0_191_27 VPWR VGND VPWR VGND sky130_ef_sc_hd__decap_12
XFILLER_0_152_1227 VPWR VGND VPWR VGND sky130_ef_sc_hd__decap_12
XFILLER_0_76_605 VPWR VGND VPWR VGND sky130_ef_sc_hd__decap_12
XFILLER_0_53_1335 VGND VGND VPWR VPWR sky130_fd_sc_hd__fill_1
XFILLER_0_5_1133 VPWR VGND VPWR VGND sky130_ef_sc_hd__decap_12
XFILLER_0_9_1291 VPWR VGND VPWR VGND sky130_ef_sc_hd__decap_12
XFILLER_0_14_1319 VPWR VGND VPWR VGND sky130_ef_sc_hd__decap_12
XFILLER_0_5_1177 VPWR VGND VPWR VGND sky130_ef_sc_hd__decap_12
XFILLER_0_163_1323 VPWR VGND VPWR VGND sky130_ef_sc_hd__decap_12
XFILLER_0_4_643 VGND VGND VPWR VPWR sky130_fd_sc_hd__fill_1
XFILLER_0_114_445 VGND VGND VPWR VPWR sky130_fd_sc_hd__decap_3
XFILLER_0_226_1044 VPWR VGND VPWR VGND sky130_ef_sc_hd__decap_12
Xinput72 psum_col1_in[15] VGND VGND VPWR VPWR net72 sky130_fd_sc_hd__buf_1
Xinput50 psum_col0_in[24] VGND VGND VPWR VPWR net50 sky130_fd_sc_hd__buf_1
Xinput61 psum_col0_in[5] VGND VGND VPWR VPWR net61 sky130_fd_sc_hd__buf_1
XFILLER_0_124_1307 VPWR VGND VPWR VGND sky130_ef_sc_hd__decap_12
Xinput83 psum_col1_in[25] VGND VGND VPWR VPWR net83 sky130_fd_sc_hd__dlymetal6s2s_1
XFILLER_0_226_1077 VGND VGND VPWR VPWR sky130_fd_sc_hd__fill_2
XFILLER_0_204_1331 VGND VGND VPWR VPWR sky130_fd_sc_hd__decap_6
Xinput94 psum_col1_in[6] VGND VGND VPWR VPWR net94 sky130_fd_sc_hd__buf_1
XFILLER_0_114_489 VPWR VGND VPWR VGND sky130_ef_sc_hd__decap_12
XFILLER_0_60_1339 VGND VGND VPWR VPWR sky130_fd_sc_hd__decap_4
XFILLER_0_200_1239 VPWR VGND VPWR VGND sky130_ef_sc_hd__decap_12
XFILLER_0_209_593 VPWR VGND VPWR VGND sky130_ef_sc_hd__decap_12
XFILLER_0_58_1213 VPWR VGND VPWR VGND sky130_ef_sc_hd__decap_12
XFILLER_0_212_725 VPWR VGND VPWR VGND sky130_ef_sc_hd__decap_12
XFILLER_0_169_629 VPWR VGND VPWR VGND sky130_ef_sc_hd__decap_12
XFILLER_0_212_769 VPWR VGND VPWR VGND sky130_ef_sc_hd__decap_12
XFILLER_0_67_605 VPWR VGND VPWR VGND sky130_ef_sc_hd__decap_12
XFILLER_0_211_1313 VPWR VGND VPWR VGND sky130_ef_sc_hd__decap_12
XFILLER_0_211_279 VGND VGND VPWR VPWR sky130_fd_sc_hd__fill_1
XFILLER_0_168_1201 VPWR VGND VPWR VGND sky130_ef_sc_hd__decap_12
XFILLER_0_82_619 VPWR VGND VPWR VGND sky130_ef_sc_hd__decap_12
XFILLER_0_109_217 VGND VGND VPWR VPWR sky130_fd_sc_hd__decap_6
XFILLER_0_192_643 VPWR VGND VPWR VGND sky130_ef_sc_hd__decap_12
XFILLER_0_209_1253 VGND VGND VPWR VPWR sky130_fd_sc_hd__fill_1
XFILLER_0_106_979 VGND VGND VPWR VPWR sky130_fd_sc_hd__fill_1
XFILLER_0_219_335 VGND VGND VPWR VPWR sky130_fd_sc_hd__fill_1
XANTENNA_input33_A load_weight VGND VGND VPWR VPWR sky130_fd_sc_hd__diode_2
XFILLER_0_175_1249 VGND VGND VPWR VPWR sky130_fd_sc_hd__decap_4
XFILLER_0_215_541 VPWR VGND VPWR VGND sky130_ef_sc_hd__decap_12
XFILLER_0_54_29 VPWR VGND VPWR VGND sky130_ef_sc_hd__decap_12
XFILLER_0_215_585 VPWR VGND VPWR VGND sky130_ef_sc_hd__decap_12
XFILLER_0_58_605 VPWR VGND VPWR VGND sky130_ef_sc_hd__decap_12
XPHY_460 VGND VGND VPWR VPWR sky130_fd_sc_hd__decap_3
XFILLER_0_2_1317 VPWR VGND VPWR VGND sky130_ef_sc_hd__decap_12
XPHY_471 VGND VGND VPWR VPWR sky130_fd_sc_hd__decap_3
XFILLER_0_5_429 VPWR VGND VPWR VGND sky130_ef_sc_hd__decap_12
XFILLER_0_81_641 VGND VGND VPWR VPWR sky130_fd_sc_hd__decap_4
XPHY_493 VGND VGND VPWR VPWR sky130_fd_sc_hd__decap_3
XPHY_482 VGND VGND VPWR VPWR sky130_fd_sc_hd__decap_3
XPHY_1092 VGND VGND VPWR VPWR sky130_fd_sc_hd__decap_3
XPHY_1081 VGND VGND VPWR VPWR sky130_fd_sc_hd__decap_3
XPHY_1070 VGND VGND VPWR VPWR sky130_fd_sc_hd__decap_3
XFILLER_0_79_15 VPWR VGND VPWR VGND sky130_ef_sc_hd__decap_12
XFILLER_0_0_1063 VGND VGND VPWR VPWR sky130_fd_sc_hd__fill_1
XFILLER_0_112_905 VPWR VGND VPWR VGND sky130_ef_sc_hd__decap_12
XFILLER_0_112_949 VPWR VGND VPWR VGND sky130_ef_sc_hd__decap_12
XFILLER_0_186_27 VGND VGND VPWR VPWR sky130_fd_sc_hd__fill_1
XFILLER_0_106_1037 VPWR VGND VPWR VGND sky130_ef_sc_hd__decap_12
XFILLER_0_186_49 VGND VGND VPWR VPWR sky130_fd_sc_hd__fill_1
XFILLER_0_0_167 VGND VGND VPWR VPWR sky130_fd_sc_hd__fill_1
XFILLER_0_95_47 VGND VGND VPWR VPWR sky130_fd_sc_hd__decap_3
XFILLER_0_119_10 VPWR VGND VPWR VGND sky130_ef_sc_hd__decap_12
XFILLER_0_225_305 VPWR VGND VPWR VGND sky130_ef_sc_hd__decap_12
XFILLER_0_28_41 VGND VGND VPWR VPWR sky130_fd_sc_hd__decap_8
XFILLER_0_225_349 VPWR VGND VPWR VGND sky130_ef_sc_hd__decap_12
XFILLER_0_49_605 VPWR VGND VPWR VGND sky130_ef_sc_hd__decap_12
XFILLER_0_7_1217 VPWR VGND VPWR VGND sky130_ef_sc_hd__decap_12
XFILLER_0_18_1263 VPWR VGND VPWR VGND sky130_ef_sc_hd__decap_12
XFILLER_0_174_643 VPWR VGND VPWR VGND sky130_ef_sc_hd__decap_12
XFILLER_0_64_619 VPWR VGND VPWR VGND sky130_ef_sc_hd__decap_12
XFILLER_0_88_1239 VPWR VGND VPWR VGND sky130_ef_sc_hd__decap_12
XFILLER_0_106_209 VPWR VGND VPWR VGND sky130_ef_sc_hd__decap_12
XFILLER_0_97_3 VPWR VGND VPWR VGND sky130_ef_sc_hd__decap_12
XFILLER_0_128_1251 VPWR VGND VPWR VGND sky130_ef_sc_hd__decap_12
XFILLER_0_114_253 VPWR VGND VPWR VGND sky130_ef_sc_hd__decap_12
XFILLER_0_25_1201 VPWR VGND VPWR VGND sky130_ef_sc_hd__decap_12
XFILLER_0_128_1295 VPWR VGND VPWR VGND sky130_ef_sc_hd__decap_12
XFILLER_0_64_1283 VPWR VGND VPWR VGND sky130_ef_sc_hd__decap_12
XFILLER_0_198_1227 VPWR VGND VPWR VGND sky130_ef_sc_hd__decap_12
XFILLER_0_40_593 VPWR VGND VPWR VGND sky130_ef_sc_hd__decap_12
XFILLER_0_25_1267 VPWR VGND VPWR VGND sky130_ef_sc_hd__decap_12
XFILLER_0_217_839 VGND VGND VPWR VPWR sky130_fd_sc_hd__fill_1
XFILLER_0_99_1335 VGND VGND VPWR VPWR sky130_fd_sc_hd__decap_8
XTAP_2803 VGND VPWR sky130_fd_sc_hd__tapvpwrvgnd_1
XTAP_2825 VGND VPWR sky130_fd_sc_hd__tapvpwrvgnd_1
XTAP_2814 VGND VPWR sky130_fd_sc_hd__tapvpwrvgnd_1
XTAP_2836 VGND VPWR sky130_fd_sc_hd__tapvpwrvgnd_1
XFILLER_0_212_533 VPWR VGND VPWR VGND sky130_ef_sc_hd__decap_12
XANTENNA_u_pe11_act_in[9] act_10_out_11_in\[9\] VGND VGND VPWR VPWR sky130_fd_sc_hd__diode_2
XTAP_2869 VGND VPWR sky130_fd_sc_hd__tapvpwrvgnd_1
XTAP_2847 VGND VPWR sky130_fd_sc_hd__tapvpwrvgnd_1
XTAP_2858 VGND VPWR sky130_fd_sc_hd__tapvpwrvgnd_1
XFILLER_0_135_1255 VPWR VGND VPWR VGND sky130_ef_sc_hd__decap_12
XFILLER_0_211_1121 VPWR VGND VPWR VGND sky130_ef_sc_hd__decap_12
XFILLER_0_32_1227 VPWR VGND VPWR VGND sky130_ef_sc_hd__decap_12
XFILLER_0_63_641 VGND VGND VPWR VPWR sky130_fd_sc_hd__decap_4
XFILLER_0_211_55 VGND VGND VPWR VPWR sky130_fd_sc_hd__fill_1
XFILLER_0_181_1253 VGND VGND VPWR VPWR sky130_fd_sc_hd__fill_1
XFILLER_0_107_1313 VPWR VGND VPWR VGND sky130_ef_sc_hd__decap_12
XFILLER_0_43_1323 VPWR VGND VPWR VGND sky130_ef_sc_hd__decap_12
XFILLER_0_222_1261 VPWR VGND VPWR VGND sky130_ef_sc_hd__decap_12
XFILLER_0_31_593 VPWR VGND VPWR VGND sky130_ef_sc_hd__decap_12
XFILLER_0_65_39 VGND VGND VPWR VPWR sky130_fd_sc_hd__decap_8
XFILLER_0_223_809 VPWR VGND VPWR VGND sky130_ef_sc_hd__decap_12
XFILLER_0_216_861 VGND VGND VPWR VPWR sky130_fd_sc_hd__decap_6
XFILLER_0_215_393 VPWR VGND VPWR VGND sky130_ef_sc_hd__decap_12
XFILLER_0_153_1311 VPWR VGND VPWR VGND sky130_ef_sc_hd__decap_12
XFILLER_0_157_6 VGND VGND VPWR VPWR sky130_fd_sc_hd__fill_2
XFILLER_0_172_29 VPWR VGND VPWR VGND sky130_ef_sc_hd__decap_12
XFILLER_0_114_1317 VPWR VGND VPWR VGND sky130_ef_sc_hd__decap_12
XFILLER_0_98_593 VPWR VGND VPWR VGND sky130_ef_sc_hd__decap_12
XFILLER_0_81_27 VPWR VGND VPWR VGND sky130_ef_sc_hd__decap_12
XFILLER_0_105_34 VPWR VGND VPWR VGND sky130_ef_sc_hd__decap_12
XFILLER_0_156_643 VPWR VGND VPWR VGND sky130_ef_sc_hd__decap_12
XFILLER_0_46_619 VPWR VGND VPWR VGND sky130_ef_sc_hd__decap_12
XFILLER_0_6_1261 VPWR VGND VPWR VGND sky130_ef_sc_hd__decap_12
XFILLER_0_112_1085 VGND VGND VPWR VPWR sky130_fd_sc_hd__decap_6
XFILLER_0_2_1147 VGND VGND VPWR VPWR sky130_fd_sc_hd__fill_1
XFILLER_0_5_237 VPWR VGND VPWR VGND sky130_ef_sc_hd__decap_12
XFILLER_0_6_749 VGND VGND VPWR VPWR sky130_fd_sc_hd__decap_6
XFILLER_0_48_1201 VPWR VGND VPWR VGND sky130_ef_sc_hd__decap_12
XPHY_290 VGND VGND VPWR VPWR sky130_fd_sc_hd__decap_3
XFILLER_0_205_3 VPWR VGND VPWR VGND sky130_ef_sc_hd__decap_12
XFILLER_0_197_15 VPWR VGND VPWR VGND sky130_ef_sc_hd__decap_12
XFILLER_0_112_713 VPWR VGND VPWR VGND sky130_ef_sc_hd__decap_12
XFILLER_0_160_1337 VGND VGND VPWR VPWR sky130_fd_sc_hd__fill_1
XFILLER_0_112_757 VPWR VGND VPWR VGND sky130_ef_sc_hd__decap_12
XFILLER_0_111_223 VGND VGND VPWR VPWR sky130_fd_sc_hd__fill_1
XFILLER_0_22_593 VPWR VGND VPWR VGND sky130_ef_sc_hd__decap_12
XFILLER_0_201_1323 VPWR VGND VPWR VGND sky130_ef_sc_hd__decap_12
XFILLER_0_225_113 VPWR VGND VPWR VGND sky130_ef_sc_hd__decap_12
XFILLER_0_146_41 VGND VGND VPWR VPWR sky130_fd_sc_hd__decap_8
XFILLER_0_12_3 VPWR VGND VPWR VGND sky130_ef_sc_hd__decap_12
XTAP_1409 VGND VPWR sky130_fd_sc_hd__tapvpwrvgnd_1
XFILLER_0_55_1249 VGND VGND VPWR VPWR sky130_fd_sc_hd__decap_4
XFILLER_0_89_593 VPWR VGND VPWR VGND sky130_ef_sc_hd__decap_12
XFILLER_0_221_385 VGND VGND VPWR VPWR sky130_fd_sc_hd__decap_6
XFILLER_0_107_529 VPWR VGND VPWR VGND sky130_ef_sc_hd__decap_12
XFILLER_0_45_641 VGND VGND VPWR VPWR sky130_fd_sc_hd__decap_4
XFILLER_0_165_1237 VPWR VGND VPWR VGND sky130_ef_sc_hd__decap_12
XFILLER_0_206_1201 VPWR VGND VPWR VGND sky130_ef_sc_hd__decap_12
XFILLER_0_60_655 VGND VGND VPWR VPWR sky130_fd_sc_hd__decap_4
XFILLER_0_13_593 VPWR VGND VPWR VGND sky130_ef_sc_hd__decap_12
XANTENNA_input135_A w10[11] VGND VGND VPWR VPWR sky130_fd_sc_hd__diode_2
XTAP_2611 VGND VPWR sky130_fd_sc_hd__tapvpwrvgnd_1
XFILLER_0_213_853 VPWR VGND VPWR VGND sky130_ef_sc_hd__decap_12
XTAP_2600 VGND VPWR sky130_fd_sc_hd__tapvpwrvgnd_1
XTAP_2633 VGND VPWR sky130_fd_sc_hd__tapvpwrvgnd_1
XFILLER_0_213_897 VPWR VGND VPWR VGND sky130_ef_sc_hd__decap_12
XTAP_2622 VGND VPWR sky130_fd_sc_hd__tapvpwrvgnd_1
XTAP_2644 VGND VPWR sky130_fd_sc_hd__tapvpwrvgnd_1
XFILLER_0_212_363 VGND VGND VPWR VPWR sky130_fd_sc_hd__fill_1
XTAP_1910 VGND VPWR sky130_fd_sc_hd__tapvpwrvgnd_1
XTAP_2655 VGND VPWR sky130_fd_sc_hd__tapvpwrvgnd_1
XTAP_2677 VGND VPWR sky130_fd_sc_hd__tapvpwrvgnd_1
XTAP_2666 VGND VPWR sky130_fd_sc_hd__tapvpwrvgnd_1
XTAP_2688 VGND VPWR sky130_fd_sc_hd__tapvpwrvgnd_1
XTAP_1921 VGND VPWR sky130_fd_sc_hd__tapvpwrvgnd_1
XTAP_1943 VGND VPWR sky130_fd_sc_hd__tapvpwrvgnd_1
XTAP_1932 VGND VPWR sky130_fd_sc_hd__tapvpwrvgnd_1
XTAP_2699 VGND VPWR sky130_fd_sc_hd__tapvpwrvgnd_1
XTAP_1976 VGND VPWR sky130_fd_sc_hd__tapvpwrvgnd_1
XFILLER_0_138_643 VPWR VGND VPWR VGND sky130_ef_sc_hd__decap_12
XTAP_1965 VGND VPWR sky130_fd_sc_hd__tapvpwrvgnd_1
XFILLER_0_28_619 VPWR VGND VPWR VGND sky130_ef_sc_hd__decap_12
XTAP_1954 VGND VPWR sky130_fd_sc_hd__tapvpwrvgnd_1
XTAP_1998 VGND VPWR sky130_fd_sc_hd__tapvpwrvgnd_1
XTAP_1987 VGND VPWR sky130_fd_sc_hd__tapvpwrvgnd_1
XFILLER_0_222_65 VPWR VGND VPWR VGND sky130_ef_sc_hd__decap_12
XFILLER_0_51_655 VGND VGND VPWR VPWR sky130_fd_sc_hd__fill_2
XFILLER_0_107_1121 VPWR VGND VPWR VGND sky130_ef_sc_hd__decap_12
XFILLER_0_76_49 VGND VGND VPWR VPWR sky130_fd_sc_hd__fill_1
XFILLER_0_76_27 VGND VGND VPWR VPWR sky130_fd_sc_hd__fill_1
XFILLER_0_222_1091 VGND VGND VPWR VPWR sky130_fd_sc_hd__fill_1
XFILLER_0_120_1343 VGND VGND VPWR VPWR sky130_fd_sc_hd__fill_1
XFILLER_0_218_1105 VPWR VGND VPWR VGND sky130_ef_sc_hd__decap_12
XFILLER_0_78_1227 VPWR VGND VPWR VGND sky130_ef_sc_hd__decap_12
XFILLER_0_223_617 VPWR VGND VPWR VGND sky130_ef_sc_hd__decap_12
XFILLER_0_183_39 VGND VGND VPWR VPWR sky130_fd_sc_hd__decap_8
XFILLER_0_92_15 VPWR VGND VPWR VGND sky130_ef_sc_hd__decap_12
XFILLER_0_218_1149 VPWR VGND VPWR VGND sky130_ef_sc_hd__decap_12
XFILLER_0_190_1319 VPWR VGND VPWR VGND sky130_ef_sc_hd__decap_12
XFILLER_0_155_3 VPWR VGND VPWR VGND sky130_ef_sc_hd__decap_12
XFILLER_0_118_1283 VPWR VGND VPWR VGND sky130_ef_sc_hd__decap_12
XFILLER_0_15_1255 VPWR VGND VPWR VGND sky130_ef_sc_hd__decap_12
XFILLER_0_89_1323 VPWR VGND VPWR VGND sky130_ef_sc_hd__decap_12
XFILLER_0_6_1091 VGND VGND VPWR VPWR sky130_fd_sc_hd__fill_1
XFILLER_0_6_513 VPWR VGND VPWR VGND sky130_ef_sc_hd__decap_12
XFILLER_0_27_641 VGND VGND VPWR VPWR sky130_fd_sc_hd__decap_4
XFILLER_0_6_557 VPWR VGND VPWR VGND sky130_ef_sc_hd__decap_12
XFILLER_0_42_655 VGND VGND VPWR VPWR sky130_fd_sc_hd__decap_4
XFILLER_0_164_1281 VGND VGND VPWR VPWR sky130_fd_sc_hd__fill_1
XFILLER_0_199_1311 VPWR VGND VPWR VGND sky130_ef_sc_hd__decap_12
XFILLER_0_112_587 VGND VGND VPWR VPWR sky130_fd_sc_hd__fill_1
XFILLER_0_1_273 VGND VGND VPWR VPWR sky130_fd_sc_hd__decap_6
XFILLER_0_61_1253 VGND VGND VPWR VPWR sky130_fd_sc_hd__fill_1
XFILLER_0_226_477 VGND VGND VPWR VPWR sky130_fd_sc_hd__decap_8
XFILLER_0_213_105 VGND VGND VPWR VPWR sky130_fd_sc_hd__decap_6
XFILLER_0_213_149 VPWR VGND VPWR VGND sky130_ef_sc_hd__decap_12
XFILLER_0_132_1225 VGND VGND VPWR VPWR sky130_fd_sc_hd__fill_1
XTAP_1239 VGND VPWR sky130_fd_sc_hd__tapvpwrvgnd_1
XTAP_1228 VGND VPWR sky130_fd_sc_hd__tapvpwrvgnd_1
XFILLER_0_33_1311 VPWR VGND VPWR VGND sky130_ef_sc_hd__decap_12
XFILLER_0_221_193 VPWR VGND VPWR VGND sky130_ef_sc_hd__decap_12
XFILLER_0_108_805 VGND VGND VPWR VPWR sky130_fd_sc_hd__decap_6
XFILLER_0_108_849 VPWR VGND VPWR VGND sky130_ef_sc_hd__decap_12
XFILLER_0_107_337 VPWR VGND VPWR VGND sky130_ef_sc_hd__decap_12
XFILLER_0_208_1307 VPWR VGND VPWR VGND sky130_ef_sc_hd__decap_12
XFILLER_0_150_605 VPWR VGND VPWR VGND sky130_ef_sc_hd__decap_12
XFILLER_0_33_655 VGND VGND VPWR VPWR sky130_fd_sc_hd__fill_2
XFILLER_0_218_923 VGND VGND VPWR VPWR sky130_fd_sc_hd__fill_1
XFILLER_0_40_1337 VGND VGND VPWR VPWR sky130_fd_sc_hd__fill_1
XFILLER_0_205_617 VPWR VGND VPWR VGND sky130_ef_sc_hd__decap_12
XANTENNA_u_pe01_valid_in valid_00_out_01_in VGND VGND VPWR VPWR sky130_fd_sc_hd__diode_2
XTAP_2463 VGND VPWR sky130_fd_sc_hd__tapvpwrvgnd_1
XTAP_2452 VGND VPWR sky130_fd_sc_hd__tapvpwrvgnd_1
XTAP_2430 VGND VPWR sky130_fd_sc_hd__tapvpwrvgnd_1
XTAP_2441 VGND VPWR sky130_fd_sc_hd__tapvpwrvgnd_1
XFILLER_0_62_29 VPWR VGND VPWR VGND sky130_ef_sc_hd__decap_12
XFILLER_0_213_1057 VGND VGND VPWR VPWR sky130_fd_sc_hd__decap_6
XTAP_2496 VGND VPWR sky130_fd_sc_hd__tapvpwrvgnd_1
XTAP_2485 VGND VPWR sky130_fd_sc_hd__tapvpwrvgnd_1
XTAP_2474 VGND VPWR sky130_fd_sc_hd__tapvpwrvgnd_1
XTAP_1740 VGND VPWR sky130_fd_sc_hd__tapvpwrvgnd_1
XTAP_1751 VGND VPWR sky130_fd_sc_hd__tapvpwrvgnd_1
XTAP_1784 VGND VPWR sky130_fd_sc_hd__tapvpwrvgnd_1
XTAP_1762 VGND VPWR sky130_fd_sc_hd__tapvpwrvgnd_1
XFILLER_0_3_1231 VGND VGND VPWR VPWR sky130_fd_sc_hd__fill_1
XTAP_1773 VGND VPWR sky130_fd_sc_hd__tapvpwrvgnd_1
XTAP_1795 VGND VPWR sky130_fd_sc_hd__tapvpwrvgnd_1
XFILLER_0_141_605 VPWR VGND VPWR VGND sky130_ef_sc_hd__decap_12
XFILLER_0_3_505 VPWR VGND VPWR VGND sky130_ef_sc_hd__decap_12
XFILLER_0_24_655 VGND VGND VPWR VPWR sky130_fd_sc_hd__decap_4
XFILLER_0_113_329 VGND VGND VPWR VPWR sky130_fd_sc_hd__decap_6
XFILLER_0_84_1275 VGND VGND VPWR VPWR sky130_fd_sc_hd__decap_6
XFILLER_0_45_1237 VPWR VGND VPWR VGND sky130_ef_sc_hd__decap_12
XFILLER_0_224_1197 VGND VGND VPWR VPWR sky130_fd_sc_hd__decap_6
XFILLER_0_220_1017 VPWR VGND VPWR VGND sky130_ef_sc_hd__decap_12
XFILLER_0_194_49 VGND VGND VPWR VPWR sky130_fd_sc_hd__fill_1
XFILLER_0_194_27 VGND VGND VPWR VPWR sky130_fd_sc_hd__fill_1
XFILLER_0_224_937 VPWR VGND VPWR VGND sky130_ef_sc_hd__decap_12
XFILLER_0_194_1263 VPWR VGND VPWR VGND sky130_ef_sc_hd__decap_12
XFILLER_0_223_447 VGND VGND VPWR VPWR sky130_fd_sc_hd__fill_1
XFILLER_0_155_1225 VPWR VGND VPWR VGND sky130_ef_sc_hd__decap_12
Xinput4 act_row0_in[12] VGND VGND VPWR VPWR net4 sky130_fd_sc_hd__clkbuf_4
XFILLER_0_36_41 VGND VGND VPWR VPWR sky130_fd_sc_hd__decap_8
XFILLER_0_211_609 VGND VGND VPWR VPWR sky130_fd_sc_hd__decap_6
XFILLER_0_91_1213 VPWR VGND VPWR VGND sky130_ef_sc_hd__decap_12
XFILLER_0_91_1279 VPWR VGND VPWR VGND sky130_ef_sc_hd__decap_12
XFILLER_0_4_1017 VPWR VGND VPWR VGND sky130_ef_sc_hd__decap_12
XFILLER_0_131_1291 VPWR VGND VPWR VGND sky130_ef_sc_hd__decap_12
XFILLER_0_6_321 VPWR VGND VPWR VGND sky130_ef_sc_hd__decap_12
XFILLER_0_166_1343 VGND VGND VPWR VPWR sky130_fd_sc_hd__fill_1
XFILLER_0_132_605 VPWR VGND VPWR VGND sky130_ef_sc_hd__decap_12
XFILLER_0_6_365 VPWR VGND VPWR VGND sky130_ef_sc_hd__decap_12
XFILLER_0_113_841 VPWR VGND VPWR VGND sky130_ef_sc_hd__decap_12
XFILLER_0_203_1237 VPWR VGND VPWR VGND sky130_ef_sc_hd__decap_12
XFILLER_0_219_709 VPWR VGND VPWR VGND sky130_ef_sc_hd__decap_12
XANTENNA_u_pe01_weight_in[14] net122 VGND VGND VPWR VPWR sky130_fd_sc_hd__diode_2
XFILLER_0_199_605 VPWR VGND VPWR VGND sky130_ef_sc_hd__decap_12
XFILLER_0_173_1303 VGND VGND VPWR VPWR sky130_fd_sc_hd__decap_6
XFILLER_0_214_469 VGND VGND VPWR VPWR sky130_fd_sc_hd__decap_6
XFILLER_0_97_647 VPWR VGND VPWR VGND sky130_ef_sc_hd__decap_12
XFILLER_0_70_1319 VPWR VGND VPWR VGND sky130_ef_sc_hd__decap_12
XPHY_801 VGND VGND VPWR VPWR sky130_fd_sc_hd__decap_3
XFILLER_0_210_697 VGND VGND VPWR VPWR sky130_fd_sc_hd__decap_3
XPHY_834 VGND VGND VPWR VPWR sky130_fd_sc_hd__decap_3
XPHY_823 VGND VGND VPWR VPWR sky130_fd_sc_hd__decap_3
XPHY_845 VGND VGND VPWR VPWR sky130_fd_sc_hd__decap_3
XPHY_812 VGND VGND VPWR VPWR sky130_fd_sc_hd__decap_3
XPHY_856 VGND VGND VPWR VPWR sky130_fd_sc_hd__decap_3
XFILLER_0_108_613 VPWR VGND VPWR VGND sky130_ef_sc_hd__decap_12
XPHY_867 VGND VGND VPWR VPWR sky130_fd_sc_hd__decap_3
XPHY_878 VGND VGND VPWR VPWR sky130_fd_sc_hd__decap_3
XPHY_889 VGND VGND VPWR VPWR sky130_fd_sc_hd__decap_3
XFILLER_0_108_657 VPWR VGND VPWR VGND sky130_ef_sc_hd__decap_12
XFILLER_0_123_605 VPWR VGND VPWR VGND sky130_ef_sc_hd__decap_12
XFILLER_0_107_167 VGND VGND VPWR VPWR sky130_fd_sc_hd__fill_1
XFILLER_0_180_1307 VPWR VGND VPWR VGND sky130_ef_sc_hd__decap_12
XFILLER_0_190_593 VPWR VGND VPWR VGND sky130_ef_sc_hd__decap_12
XFILLER_0_104_841 VPWR VGND VPWR VGND sky130_ef_sc_hd__decap_12
XANTENNA_input63_A psum_col0_in[7] VGND VGND VPWR VPWR sky130_fd_sc_hd__diode_2
XFILLER_0_21_647 VGND VGND VPWR VPWR sky130_fd_sc_hd__decap_8
XFILLER_0_44_1281 VGND VGND VPWR VPWR sky130_fd_sc_hd__fill_1
XFILLER_0_178_1225 VGND VGND VPWR VPWR sky130_fd_sc_hd__fill_1
XFILLER_0_189_9 VGND VGND VPWR VPWR sky130_fd_sc_hd__fill_2
XFILLER_0_79_1311 VPWR VGND VPWR VGND sky130_ef_sc_hd__decap_12
XFILLER_0_219_1233 VPWR VGND VPWR VGND sky130_ef_sc_hd__decap_12
XFILLER_0_215_1119 VGND VGND VPWR VPWR sky130_fd_sc_hd__fill_1
XFILLER_0_214_981 VPWR VGND VPWR VGND sky130_ef_sc_hd__decap_12
XFILLER_0_180_29 VPWR VGND VPWR VGND sky130_ef_sc_hd__decap_12
XTAP_2271 VGND VPWR sky130_fd_sc_hd__tapvpwrvgnd_1
XTAP_2260 VGND VPWR sky130_fd_sc_hd__tapvpwrvgnd_1
XFILLER_0_115_1253 VGND VGND VPWR VPWR sky130_fd_sc_hd__fill_1
XFILLER_0_189_1343 VGND VGND VPWR VPWR sky130_fd_sc_hd__fill_1
XTAP_2293 VGND VPWR sky130_fd_sc_hd__tapvpwrvgnd_1
XTAP_2282 VGND VPWR sky130_fd_sc_hd__tapvpwrvgnd_1
XFILLER_0_8_619 VPWR VGND VPWR VGND sky130_ef_sc_hd__decap_12
XFILLER_0_5_1337 VGND VGND VPWR VPWR sky130_fd_sc_hd__decap_6
XTAP_1581 VGND VPWR sky130_fd_sc_hd__tapvpwrvgnd_1
XTAP_1570 VGND VPWR sky130_fd_sc_hd__tapvpwrvgnd_1
XFILLER_0_12_1225 VGND VGND VPWR VPWR sky130_fd_sc_hd__fill_1
XTAP_1592 VGND VPWR sky130_fd_sc_hd__tapvpwrvgnd_1
XFILLER_0_4_825 VPWR VGND VPWR VGND sky130_ef_sc_hd__decap_12
XFILLER_0_86_1337 VGND VGND VPWR VPWR sky130_fd_sc_hd__fill_1
XFILLER_0_118_3 VPWR VGND VPWR VGND sky130_ef_sc_hd__decap_12
XFILLER_0_181_593 VPWR VGND VPWR VGND sky130_ef_sc_hd__decap_12
XFILLER_0_3_335 VGND VGND VPWR VPWR sky130_fd_sc_hd__fill_1
XFILLER_0_4_869 VPWR VGND VPWR VGND sky130_ef_sc_hd__decap_12
XFILLER_0_113_137 VPWR VGND VPWR VGND sky130_ef_sc_hd__decap_12
XFILLER_0_109_1057 VGND VGND VPWR VPWR sky130_fd_sc_hd__decap_6
XFILLER_0_122_1213 VPWR VGND VPWR VGND sky130_ef_sc_hd__decap_12
XFILLER_0_110_811 VGND VGND VPWR VPWR sky130_fd_sc_hd__fill_1
XFILLER_0_202_1281 VGND VGND VPWR VPWR sky130_fd_sc_hd__fill_1
XFILLER_0_224_701 VPWR VGND VPWR VGND sky130_ef_sc_hd__decap_12
XFILLER_0_157_1309 VGND VGND VPWR VPWR sky130_fd_sc_hd__fill_1
XFILLER_0_196_619 VPWR VGND VPWR VGND sky130_ef_sc_hd__decap_12
XFILLER_0_211_417 VPWR VGND VPWR VGND sky130_ef_sc_hd__decap_12
XFILLER_0_2_53 VPWR VGND VPWR VGND sky130_ef_sc_hd__decap_12
XFILLER_0_79_647 VGND VGND VPWR VPWR sky130_fd_sc_hd__decap_8
XFILLER_0_154_41 VGND VGND VPWR VPWR sky130_fd_sc_hd__decap_8
XFILLER_0_94_617 VGND VGND VPWR VPWR sky130_fd_sc_hd__fill_1
XFILLER_0_2_97 VPWR VGND VPWR VGND sky130_ef_sc_hd__decap_12
XFILLER_0_220_973 VGND VGND VPWR VPWR sky130_fd_sc_hd__decap_6
XPHY_119 VGND VGND VPWR VPWR sky130_fd_sc_hd__decap_3
XPHY_108 VGND VGND VPWR VPWR sky130_fd_sc_hd__decap_3
XFILLER_0_7_641 VGND VGND VPWR VPWR sky130_fd_sc_hd__decap_3
XFILLER_0_7_685 VPWR VGND VPWR VGND sky130_ef_sc_hd__decap_12
XFILLER_0_172_593 VPWR VGND VPWR VGND sky130_ef_sc_hd__decap_12
XFILLER_0_6_195 VGND VGND VPWR VPWR sky130_fd_sc_hd__fill_1
XFILLER_0_104_137 VGND VGND VPWR VPWR sky130_fd_sc_hd__decap_3
XFILLER_0_120_619 VPWR VGND VPWR VGND sky130_ef_sc_hd__decap_12
XFILLER_0_113_671 VGND VGND VPWR VPWR sky130_fd_sc_hd__fill_1
XFILLER_0_219_517 VPWR VGND VPWR VGND sky130_ef_sc_hd__decap_12
Xoutput182 net182 VGND VGND VPWR VPWR psum_col0_out[25] sky130_fd_sc_hd__clkbuf_4
Xoutput193 net193 VGND VGND VPWR VPWR psum_col0_out[6] sky130_fd_sc_hd__clkbuf_4
Xoutput171 net171 VGND VGND VPWR VPWR psum_col0_out[15] sky130_fd_sc_hd__clkbuf_4
XFILLER_0_177_1291 VPWR VGND VPWR VGND sky130_ef_sc_hd__decap_12
XFILLER_0_214_233 VPWR VGND VPWR VGND sky130_ef_sc_hd__decap_12
XFILLER_0_214_277 VPWR VGND VPWR VGND sky130_ef_sc_hd__decap_12
XFILLER_0_138_1275 VGND VGND VPWR VPWR sky130_fd_sc_hd__decap_6
XFILLER_0_214_1141 VGND VGND VPWR VPWR sky130_fd_sc_hd__decap_6
XFILLER_0_211_951 VGND VGND VPWR VPWR sky130_fd_sc_hd__fill_1
XFILLER_0_85_617 VPWR VGND VPWR VGND sky130_ef_sc_hd__decap_12
XFILLER_0_35_1225 VPWR VGND VPWR VGND sky130_ef_sc_hd__decap_12
XFILLER_0_74_1263 VPWR VGND VPWR VGND sky130_ef_sc_hd__decap_12
XFILLER_0_214_1185 VPWR VGND VPWR VGND sky130_ef_sc_hd__decap_12
XFILLER_0_195_641 VGND VGND VPWR VPWR sky130_fd_sc_hd__decap_4
XFILLER_0_210_461 VPWR VGND VPWR VGND sky130_ef_sc_hd__decap_12
XANTENNA_u_pe11_weight_in[2] net157 VGND VGND VPWR VPWR sky130_fd_sc_hd__diode_2
XPHY_620 VGND VGND VPWR VPWR sky130_fd_sc_hd__decap_3
XFILLER_0_210_1027 VGND VGND VPWR VPWR sky130_fd_sc_hd__fill_1
XFILLER_0_214_77 VGND VGND VPWR VPWR sky130_fd_sc_hd__decap_6
XPHY_642 VGND VGND VPWR VPWR sky130_fd_sc_hd__decap_3
XPHY_631 VGND VGND VPWR VPWR sky130_fd_sc_hd__decap_3
XPHY_653 VGND VGND VPWR VPWR sky130_fd_sc_hd__decap_3
XFILLER_0_109_933 VPWR VGND VPWR VGND sky130_ef_sc_hd__decap_12
XPHY_664 VGND VGND VPWR VPWR sky130_fd_sc_hd__decap_3
XFILLER_0_108_421 VPWR VGND VPWR VGND sky130_ef_sc_hd__decap_12
XPHY_675 VGND VGND VPWR VPWR sky130_fd_sc_hd__decap_3
XPHY_686 VGND VGND VPWR VPWR sky130_fd_sc_hd__decap_3
XPHY_697 VGND VGND VPWR VPWR sky130_fd_sc_hd__decap_3
XFILLER_0_110_1161 VPWR VGND VPWR VGND sky130_ef_sc_hd__decap_12
XFILLER_0_109_977 VPWR VGND VPWR VGND sky130_ef_sc_hd__decap_12
XFILLER_0_184_1251 VPWR VGND VPWR VGND sky130_ef_sc_hd__decap_12
XFILLER_0_145_1213 VPWR VGND VPWR VGND sky130_ef_sc_hd__decap_12
XFILLER_0_163_593 VPWR VGND VPWR VGND sky130_ef_sc_hd__decap_12
XFILLER_0_0_1267 VGND VGND VPWR VPWR sky130_fd_sc_hd__decap_8
XFILLER_0_0_1289 VGND VGND VPWR VPWR sky130_fd_sc_hd__decap_8
XFILLER_0_11_1291 VPWR VGND VPWR VGND sky130_ef_sc_hd__decap_12
XFILLER_0_184_1295 VPWR VGND VPWR VGND sky130_ef_sc_hd__decap_12
XFILLER_0_46_1343 VGND VGND VPWR VPWR sky130_fd_sc_hd__fill_1
XFILLER_0_81_1201 VPWR VGND VPWR VGND sky130_ef_sc_hd__decap_12
XFILLER_0_225_1281 VGND VGND VPWR VPWR sky130_fd_sc_hd__decap_6
XFILLER_0_221_1101 VPWR VGND VPWR VGND sky130_ef_sc_hd__decap_12
XFILLER_0_145_1279 VPWR VGND VPWR VGND sky130_ef_sc_hd__decap_12
XFILLER_0_1_839 VGND VGND VPWR VPWR sky130_fd_sc_hd__fill_1
XFILLER_0_221_1145 VPWR VGND VPWR VGND sky130_ef_sc_hd__decap_12
XFILLER_0_81_1267 VPWR VGND VPWR VGND sky130_ef_sc_hd__decap_12
XFILLER_0_221_1189 VPWR VGND VPWR VGND sky130_ef_sc_hd__decap_12
XFILLER_0_84_49 VGND VGND VPWR VPWR sky130_fd_sc_hd__fill_1
XFILLER_0_219_1063 VGND VGND VPWR VPWR sky130_fd_sc_hd__fill_1
XFILLER_0_156_1331 VGND VGND VPWR VPWR sky130_fd_sc_hd__decap_6
XFILLER_0_191_1255 VPWR VGND VPWR VGND sky130_ef_sc_hd__decap_12
XFILLER_0_178_619 VPWR VGND VPWR VGND sky130_ef_sc_hd__decap_12
XFILLER_0_53_1303 VGND VGND VPWR VPWR sky130_fd_sc_hd__decap_6
XFILLER_0_191_39 VGND VGND VPWR VPWR sky130_fd_sc_hd__decap_8
XFILLER_0_152_1239 VPWR VGND VPWR VGND sky130_ef_sc_hd__decap_12
XFILLER_0_76_617 VGND VGND VPWR VPWR sky130_fd_sc_hd__fill_1
XFILLER_0_5_1101 VPWR VGND VPWR VGND sky130_ef_sc_hd__decap_12
XTAP_2090 VGND VPWR sky130_fd_sc_hd__tapvpwrvgnd_1
XFILLER_0_5_1145 VPWR VGND VPWR VGND sky130_ef_sc_hd__decap_12
XFILLER_0_1_1009 VPWR VGND VPWR VGND sky130_ef_sc_hd__decap_12
XFILLER_0_5_1189 VPWR VGND VPWR VGND sky130_ef_sc_hd__decap_12
XFILLER_0_140_10 VPWR VGND VPWR VGND sky130_ef_sc_hd__decap_12
Xinput40 psum_col0_in[15] VGND VGND VPWR VPWR net40 sky130_fd_sc_hd__buf_1
XFILLER_0_154_593 VPWR VGND VPWR VGND sky130_ef_sc_hd__decap_12
XFILLER_0_226_1056 VGND VGND VPWR VPWR sky130_fd_sc_hd__fill_1
Xinput73 psum_col1_in[16] VGND VGND VPWR VPWR net73 sky130_fd_sc_hd__buf_1
Xinput51 psum_col0_in[25] VGND VGND VPWR VPWR net51 sky130_fd_sc_hd__buf_1
Xinput62 psum_col0_in[6] VGND VGND VPWR VPWR net62 sky130_fd_sc_hd__buf_1
XFILLER_0_163_1335 VGND VGND VPWR VPWR sky130_fd_sc_hd__decap_8
XFILLER_0_102_619 VPWR VGND VPWR VGND sky130_ef_sc_hd__decap_12
Xinput84 psum_col1_in[26] VGND VGND VPWR VPWR net84 sky130_fd_sc_hd__dlymetal6s2s_1
Xinput95 psum_col1_in[7] VGND VGND VPWR VPWR net95 sky130_fd_sc_hd__buf_1
XFILLER_0_124_1319 VPWR VGND VPWR VGND sky130_ef_sc_hd__decap_12
XFILLER_0_4_699 VGND VGND VPWR VPWR sky130_fd_sc_hd__fill_1
XFILLER_0_204_1343 VGND VGND VPWR VPWR sky130_fd_sc_hd__fill_1
XFILLER_0_60_1307 VPWR VGND VPWR VGND sky130_ef_sc_hd__decap_12
XFILLER_0_224_531 VGND VGND VPWR VPWR sky130_fd_sc_hd__fill_1
XFILLER_0_58_1225 VGND VGND VPWR VPWR sky130_fd_sc_hd__fill_1
XFILLER_0_212_737 VPWR VGND VPWR VGND sky130_ef_sc_hd__decap_12
XFILLER_0_211_225 VPWR VGND VPWR VGND sky130_ef_sc_hd__decap_12
XFILLER_0_170_1339 VGND VGND VPWR VPWR sky130_fd_sc_hd__decap_4
XFILLER_0_67_617 VPWR VGND VPWR VGND sky130_ef_sc_hd__decap_12
XFILLER_0_211_1325 VPWR VGND VPWR VGND sky130_ef_sc_hd__decap_12
XFILLER_0_177_641 VGND VGND VPWR VPWR sky130_fd_sc_hd__decap_4
XFILLER_0_220_781 VPWR VGND VPWR VGND sky130_ef_sc_hd__decap_12
XFILLER_0_192_655 VGND VGND VPWR VPWR sky130_fd_sc_hd__decap_4
XFILLER_0_168_1213 VPWR VGND VPWR VGND sky130_ef_sc_hd__decap_12
XFILLER_0_106_925 VPWR VGND VPWR VGND sky130_ef_sc_hd__decap_12
XFILLER_0_90_631 VPWR VGND VPWR VGND sky130_ef_sc_hd__decap_12
XFILLER_0_69_1343 VGND VGND VPWR VPWR sky130_fd_sc_hd__fill_1
XFILLER_0_145_593 VPWR VGND VPWR VGND sky130_ef_sc_hd__decap_12
XFILLER_0_101_641 VGND VGND VPWR VPWR sky130_fd_sc_hd__decap_4
XFILLER_0_179_1331 VGND VGND VPWR VPWR sky130_fd_sc_hd__fill_2
XFILLER_0_216_1203 VGND VGND VPWR VPWR sky130_fd_sc_hd__fill_1
XFILLER_0_215_553 VGND VGND VPWR VPWR sky130_fd_sc_hd__decap_6
XANTENNA_input26_A act_row1_in[3] VGND VGND VPWR VPWR sky130_fd_sc_hd__diode_2
XFILLER_0_215_597 VPWR VGND VPWR VGND sky130_ef_sc_hd__decap_12
XFILLER_0_225_10 VPWR VGND VPWR VGND sky130_ef_sc_hd__decap_12
XFILLER_0_37_1309 VGND VGND VPWR VPWR sky130_fd_sc_hd__fill_1
XFILLER_0_225_54 VGND VGND VPWR VPWR sky130_fd_sc_hd__fill_2
XFILLER_0_58_617 VGND VGND VPWR VPWR sky130_fd_sc_hd__fill_1
XFILLER_0_70_29 VPWR VGND VPWR VGND sky130_ef_sc_hd__decap_12
XFILLER_0_183_655 VGND VGND VPWR VPWR sky130_fd_sc_hd__fill_2
XFILLER_0_109_741 VPWR VGND VPWR VGND sky130_ef_sc_hd__decap_12
XPHY_461 VGND VGND VPWR VPWR sky130_fd_sc_hd__decap_3
XPHY_450 VGND VGND VPWR VPWR sky130_fd_sc_hd__decap_3
XFILLER_0_2_1329 VPWR VGND VPWR VGND sky130_ef_sc_hd__decap_12
XPHY_472 VGND VGND VPWR VPWR sky130_fd_sc_hd__decap_3
XPHY_483 VGND VGND VPWR VPWR sky130_fd_sc_hd__decap_3
XPHY_494 VGND VGND VPWR VPWR sky130_fd_sc_hd__decap_3
XFILLER_0_108_251 VGND VGND VPWR VPWR sky130_fd_sc_hd__fill_1
XPHY_1060 VGND VGND VPWR VPWR sky130_fd_sc_hd__decap_3
XPHY_1082 VGND VGND VPWR VPWR sky130_fd_sc_hd__decap_3
XPHY_1071 VGND VGND VPWR VPWR sky130_fd_sc_hd__decap_3
XFILLER_0_136_593 VPWR VGND VPWR VGND sky130_ef_sc_hd__decap_12
XFILLER_0_109_785 VPWR VGND VPWR VGND sky130_ef_sc_hd__decap_12
XFILLER_0_79_27 VPWR VGND VPWR VGND sky130_ef_sc_hd__decap_12
XPHY_1093 VGND VGND VPWR VPWR sky130_fd_sc_hd__decap_3
XFILLER_0_112_917 VGND VGND VPWR VPWR sky130_fd_sc_hd__decap_6
XFILLER_0_106_1005 VPWR VGND VPWR VGND sky130_ef_sc_hd__decap_12
XFILLER_0_111_405 VPWR VGND VPWR VGND sky130_ef_sc_hd__decap_12
XFILLER_0_106_1049 VPWR VGND VPWR VGND sky130_ef_sc_hd__decap_12
XFILLER_0_111_449 VPWR VGND VPWR VGND sky130_ef_sc_hd__decap_12
XFILLER_0_95_15 VPWR VGND VPWR VGND sky130_ef_sc_hd__decap_12
XFILLER_0_225_317 VPWR VGND VPWR VGND sky130_ef_sc_hd__decap_12
XFILLER_0_119_22 VPWR VGND VPWR VGND sky130_ef_sc_hd__decap_12
XANTENNA_u_pe00_psum_in[4] net60 VGND VGND VPWR VPWR sky130_fd_sc_hd__diode_2
XFILLER_0_44_41 VGND VGND VPWR VPWR sky130_fd_sc_hd__decap_8
XFILLER_0_113_1009 VPWR VGND VPWR VGND sky130_ef_sc_hd__decap_12
XFILLER_0_159_641 VGND VGND VPWR VPWR sky130_fd_sc_hd__decap_4
XFILLER_0_49_617 VPWR VGND VPWR VGND sky130_ef_sc_hd__decap_12
XFILLER_0_7_1229 VGND VGND VPWR VPWR sky130_fd_sc_hd__decap_3
XFILLER_0_57_1291 VPWR VGND VPWR VGND sky130_ef_sc_hd__decap_12
XFILLER_0_18_1275 VGND VGND VPWR VPWR sky130_fd_sc_hd__decap_6
XFILLER_0_174_655 VGND VGND VPWR VPWR sky130_fd_sc_hd__decap_4
XFILLER_0_72_631 VPWR VGND VPWR VGND sky130_ef_sc_hd__decap_12
XFILLER_0_127_593 VPWR VGND VPWR VGND sky130_ef_sc_hd__decap_12
XFILLER_0_8_41 VGND VGND VPWR VPWR sky130_fd_sc_hd__decap_8
XFILLER_0_5_953 VPWR VGND VPWR VGND sky130_ef_sc_hd__decap_12
XFILLER_0_114_221 VGND VGND VPWR VPWR sky130_fd_sc_hd__decap_3
XFILLER_0_128_1263 VPWR VGND VPWR VGND sky130_ef_sc_hd__decap_12
XFILLER_0_114_265 VPWR VGND VPWR VGND sky130_ef_sc_hd__decap_12
XFILLER_0_25_1213 VPWR VGND VPWR VGND sky130_ef_sc_hd__decap_12
XFILLER_0_64_1251 VPWR VGND VPWR VGND sky130_ef_sc_hd__decap_12
XFILLER_0_198_1239 VPWR VGND VPWR VGND sky130_ef_sc_hd__decap_12
XFILLER_0_99_1303 VGND VGND VPWR VPWR sky130_fd_sc_hd__decap_6
XFILLER_0_64_1295 VPWR VGND VPWR VGND sky130_ef_sc_hd__decap_12
XFILLER_0_0_691 VGND VGND VPWR VPWR sky130_fd_sc_hd__decap_8
XFILLER_0_25_1279 VPWR VGND VPWR VGND sky130_ef_sc_hd__decap_12
XFILLER_0_225_895 VGND VGND VPWR VPWR sky130_fd_sc_hd__fill_1
XFILLER_0_212_501 VPWR VGND VPWR VGND sky130_ef_sc_hd__decap_12
XFILLER_0_135_1201 VPWR VGND VPWR VGND sky130_ef_sc_hd__decap_12
XTAP_2815 VGND VPWR sky130_fd_sc_hd__tapvpwrvgnd_1
XTAP_2837 VGND VPWR sky130_fd_sc_hd__tapvpwrvgnd_1
XFILLER_0_212_545 VPWR VGND VPWR VGND sky130_ef_sc_hd__decap_12
XTAP_2826 VGND VPWR sky130_fd_sc_hd__tapvpwrvgnd_1
XTAP_2804 VGND VPWR sky130_fd_sc_hd__tapvpwrvgnd_1
XFILLER_0_174_1283 VPWR VGND VPWR VGND sky130_ef_sc_hd__decap_12
XANTENNA_u_pe11_act_in[8] act_10_out_11_in\[8\] VGND VGND VPWR VPWR sky130_fd_sc_hd__diode_2
XTAP_2848 VGND VPWR sky130_fd_sc_hd__tapvpwrvgnd_1
XTAP_2859 VGND VPWR sky130_fd_sc_hd__tapvpwrvgnd_1
XFILLER_0_212_589 VPWR VGND VPWR VGND sky130_ef_sc_hd__decap_12
XFILLER_0_135_1267 VPWR VGND VPWR VGND sky130_ef_sc_hd__decap_12
XFILLER_0_36_1331 VGND VGND VPWR VPWR sky130_fd_sc_hd__decap_6
XFILLER_0_211_1133 VPWR VGND VPWR VGND sky130_ef_sc_hd__decap_12
XFILLER_0_71_1255 VPWR VGND VPWR VGND sky130_ef_sc_hd__decap_12
XFILLER_0_165_655 VGND VGND VPWR VPWR sky130_fd_sc_hd__fill_2
XFILLER_0_32_1239 VPWR VGND VPWR VGND sky130_ef_sc_hd__decap_12
XFILLER_0_211_1177 VPWR VGND VPWR VGND sky130_ef_sc_hd__decap_12
XFILLER_0_118_593 VPWR VGND VPWR VGND sky130_ef_sc_hd__decap_12
XFILLER_0_106_755 VGND VGND VPWR VPWR sky130_fd_sc_hd__fill_1
XFILLER_0_107_1325 VGND VGND VPWR VPWR sky130_fd_sc_hd__decap_8
XFILLER_0_142_1227 VPWR VGND VPWR VGND sky130_ef_sc_hd__decap_12
XFILLER_0_219_111 VGND VGND VPWR VPWR sky130_fd_sc_hd__fill_1
XFILLER_0_43_1335 VGND VGND VPWR VPWR sky130_fd_sc_hd__decap_8
XFILLER_0_222_1273 VPWR VGND VPWR VGND sky130_ef_sc_hd__decap_12
XFILLER_0_218_1309 VGND VGND VPWR VPWR sky130_fd_sc_hd__decap_6
XFILLER_0_222_309 VPWR VGND VPWR VGND sky130_ef_sc_hd__decap_12
XFILLER_0_215_361 VPWR VGND VPWR VGND sky130_ef_sc_hd__decap_12
XFILLER_0_153_1323 VPWR VGND VPWR VGND sky130_ef_sc_hd__decap_12
XFILLER_0_114_1329 VPWR VGND VPWR VGND sky130_ef_sc_hd__decap_12
XFILLER_0_81_39 VGND VGND VPWR VPWR sky130_fd_sc_hd__decap_8
XFILLER_0_105_46 VGND VGND VPWR VPWR sky130_fd_sc_hd__decap_8
XFILLER_0_105_57 VPWR VGND VPWR VGND sky130_ef_sc_hd__decap_12
XFILLER_0_156_655 VGND VGND VPWR VPWR sky130_fd_sc_hd__decap_4
XFILLER_0_6_1273 VPWR VGND VPWR VGND sky130_ef_sc_hd__decap_12
XFILLER_0_50_1339 VGND VGND VPWR VPWR sky130_fd_sc_hd__decap_4
XFILLER_0_54_631 VPWR VGND VPWR VGND sky130_ef_sc_hd__decap_12
XFILLER_0_171_647 VGND VGND VPWR VPWR sky130_fd_sc_hd__decap_8
XPHY_280 VGND VGND VPWR VPWR sky130_fd_sc_hd__decap_3
XFILLER_0_5_205 VPWR VGND VPWR VGND sky130_ef_sc_hd__decap_12
XPHY_291 VGND VGND VPWR VPWR sky130_fd_sc_hd__decap_3
XFILLER_0_5_249 VPWR VGND VPWR VGND sky130_ef_sc_hd__decap_12
XFILLER_0_48_1213 VPWR VGND VPWR VGND sky130_ef_sc_hd__decap_12
XFILLER_0_197_27 VPWR VGND VPWR VGND sky130_ef_sc_hd__decap_12
XFILLER_0_112_725 VPWR VGND VPWR VGND sky130_ef_sc_hd__decap_12
XFILLER_0_2_923 VGND VGND VPWR VPWR sky130_fd_sc_hd__fill_1
XFILLER_0_100_3 VPWR VGND VPWR VGND sky130_ef_sc_hd__decap_12
XFILLER_0_112_769 VPWR VGND VPWR VGND sky130_ef_sc_hd__decap_12
XFILLER_0_111_279 VGND VGND VPWR VPWR sky130_fd_sc_hd__fill_1
XFILLER_0_201_1335 VGND VGND VPWR VPWR sky130_fd_sc_hd__decap_8
XFILLER_0_226_626 VPWR VGND VPWR VGND sky130_ef_sc_hd__decap_12
XFILLER_0_225_125 VPWR VGND VPWR VGND sky130_ef_sc_hd__decap_12
XFILLER_0_158_1201 VPWR VGND VPWR VGND sky130_ef_sc_hd__decap_12
XFILLER_0_225_169 VPWR VGND VPWR VGND sky130_ef_sc_hd__decap_12
XFILLER_0_7_1037 VPWR VGND VPWR VGND sky130_ef_sc_hd__decap_12
XFILLER_0_162_41 VGND VGND VPWR VPWR sky130_fd_sc_hd__decap_8
XFILLER_0_147_655 VGND VGND VPWR VPWR sky130_fd_sc_hd__fill_2
XFILLER_0_165_1249 VGND VGND VPWR VPWR sky130_fd_sc_hd__decap_4
XFILLER_0_206_1213 VPWR VGND VPWR VGND sky130_ef_sc_hd__decap_12
XFILLER_0_5_783 VGND VGND VPWR VPWR sky130_fd_sc_hd__fill_1
XFILLER_0_217_615 VGND VGND VPWR VPWR sky130_fd_sc_hd__fill_1
XFILLER_0_3_7 VGND VGND VPWR VPWR sky130_fd_sc_hd__fill_2
XFILLER_0_213_821 VPWR VGND VPWR VGND sky130_ef_sc_hd__decap_12
XTAP_2612 VGND VPWR sky130_fd_sc_hd__tapvpwrvgnd_1
XTAP_2601 VGND VPWR sky130_fd_sc_hd__tapvpwrvgnd_1
XANTENNA_input128_A w01[5] VGND VGND VPWR VPWR sky130_fd_sc_hd__diode_2
XTAP_2634 VGND VPWR sky130_fd_sc_hd__tapvpwrvgnd_1
XFILLER_0_213_865 VPWR VGND VPWR VGND sky130_ef_sc_hd__decap_12
XTAP_2623 VGND VPWR sky130_fd_sc_hd__tapvpwrvgnd_1
XTAP_2645 VGND VPWR sky130_fd_sc_hd__tapvpwrvgnd_1
XTAP_1900 VGND VPWR sky130_fd_sc_hd__tapvpwrvgnd_1
XTAP_2656 VGND VPWR sky130_fd_sc_hd__tapvpwrvgnd_1
XTAP_2678 VGND VPWR sky130_fd_sc_hd__tapvpwrvgnd_1
XTAP_2667 VGND VPWR sky130_fd_sc_hd__tapvpwrvgnd_1
XTAP_1922 VGND VPWR sky130_fd_sc_hd__tapvpwrvgnd_1
XTAP_1933 VGND VPWR sky130_fd_sc_hd__tapvpwrvgnd_1
XTAP_1911 VGND VPWR sky130_fd_sc_hd__tapvpwrvgnd_1
XTAP_2689 VGND VPWR sky130_fd_sc_hd__tapvpwrvgnd_1
XTAP_1977 VGND VPWR sky130_fd_sc_hd__tapvpwrvgnd_1
XTAP_1966 VGND VPWR sky130_fd_sc_hd__tapvpwrvgnd_1
XTAP_1944 VGND VPWR sky130_fd_sc_hd__tapvpwrvgnd_1
XTAP_1955 VGND VPWR sky130_fd_sc_hd__tapvpwrvgnd_1
XTAP_1999 VGND VPWR sky130_fd_sc_hd__tapvpwrvgnd_1
XFILLER_0_138_655 VGND VGND VPWR VPWR sky130_fd_sc_hd__decap_4
XTAP_1988 VGND VPWR sky130_fd_sc_hd__tapvpwrvgnd_1
XFILLER_0_36_631 VPWR VGND VPWR VGND sky130_ef_sc_hd__decap_12
XANTENNA_input93_A psum_col1_in[5] VGND VGND VPWR VPWR sky130_fd_sc_hd__diode_2
XFILLER_0_222_77 VGND VGND VPWR VPWR sky130_fd_sc_hd__decap_6
XFILLER_0_153_647 VGND VGND VPWR VPWR sky130_fd_sc_hd__decap_8
XFILLER_0_3_709 VPWR VGND VPWR VGND sky130_ef_sc_hd__decap_12
XFILLER_0_51_645 VGND VGND VPWR VPWR sky130_fd_sc_hd__fill_1
XFILLER_0_107_1133 VPWR VGND VPWR VGND sky130_ef_sc_hd__decap_12
XFILLER_0_107_1177 VPWR VGND VPWR VGND sky130_ef_sc_hd__decap_12
XFILLER_0_78_1239 VPWR VGND VPWR VGND sky130_ef_sc_hd__decap_12
XFILLER_0_218_1117 VPWR VGND VPWR VGND sky130_ef_sc_hd__decap_12
XFILLER_0_223_629 VPWR VGND VPWR VGND sky130_ef_sc_hd__decap_12
XFILLER_0_92_27 VGND VGND VPWR VPWR sky130_fd_sc_hd__fill_1
XFILLER_0_216_681 VPWR VGND VPWR VGND sky130_ef_sc_hd__decap_12
XFILLER_0_222_139 VGND VGND VPWR VPWR sky130_fd_sc_hd__fill_1
XFILLER_0_92_49 VGND VGND VPWR VPWR sky130_fd_sc_hd__fill_1
XFILLER_0_118_1251 VPWR VGND VPWR VGND sky130_ef_sc_hd__decap_12
XFILLER_0_118_1295 VPWR VGND VPWR VGND sky130_ef_sc_hd__decap_12
XFILLER_0_15_1201 VPWR VGND VPWR VGND sky130_ef_sc_hd__decap_12
XFILLER_0_148_3 VPWR VGND VPWR VGND sky130_ef_sc_hd__decap_12
XFILLER_0_188_1227 VPWR VGND VPWR VGND sky130_ef_sc_hd__decap_12
XFILLER_0_54_1283 VPWR VGND VPWR VGND sky130_ef_sc_hd__decap_12
XFILLER_0_89_1335 VGND VGND VPWR VPWR sky130_fd_sc_hd__fill_1
XFILLER_0_129_655 VGND VGND VPWR VPWR sky130_fd_sc_hd__fill_2
XFILLER_0_15_1267 VPWR VGND VPWR VGND sky130_ef_sc_hd__decap_12
XFILLER_0_6_525 VGND VGND VPWR VPWR sky130_fd_sc_hd__decap_6
XFILLER_0_6_569 VPWR VGND VPWR VGND sky130_ef_sc_hd__decap_12
XFILLER_0_112_533 VPWR VGND VPWR VGND sky130_ef_sc_hd__decap_12
XFILLER_0_199_1323 VPWR VGND VPWR VGND sky130_ef_sc_hd__decap_12
XFILLER_0_125_1255 VPWR VGND VPWR VGND sky130_ef_sc_hd__decap_12
XFILLER_0_22_1227 VPWR VGND VPWR VGND sky130_ef_sc_hd__decap_12
XFILLER_0_96_1339 VGND VGND VPWR VPWR sky130_fd_sc_hd__decap_4
XFILLER_0_210_813 VPWR VGND VPWR VGND sky130_ef_sc_hd__decap_12
XFILLER_0_221_161 VGND VGND VPWR VPWR sky130_fd_sc_hd__decap_6
XFILLER_0_171_1253 VGND VGND VPWR VPWR sky130_fd_sc_hd__fill_1
XTAP_1218 VGND VPWR sky130_fd_sc_hd__tapvpwrvgnd_1
XTAP_1229 VGND VPWR sky130_fd_sc_hd__tapvpwrvgnd_1
XFILLER_0_33_1323 VPWR VGND VPWR VGND sky130_ef_sc_hd__decap_12
XFILLER_0_212_1261 VPWR VGND VPWR VGND sky130_ef_sc_hd__decap_12
XFILLER_0_18_631 VPWR VGND VPWR VGND sky130_ef_sc_hd__decap_12
XFILLER_0_107_305 VPWR VGND VPWR VGND sky130_ef_sc_hd__decap_12
XFILLER_0_135_647 VGND VGND VPWR VPWR sky130_fd_sc_hd__decap_8
XFILLER_0_107_349 VPWR VGND VPWR VGND sky130_ef_sc_hd__decap_12
XFILLER_0_208_1319 VPWR VGND VPWR VGND sky130_ef_sc_hd__decap_12
XFILLER_0_150_617 VGND VGND VPWR VPWR sky130_fd_sc_hd__fill_1
XFILLER_0_33_645 VGND VGND VPWR VPWR sky130_fd_sc_hd__fill_1
XFILLER_0_143_1311 VPWR VGND VPWR VGND sky130_ef_sc_hd__decap_12
XFILLER_0_104_1317 VPWR VGND VPWR VGND sky130_ef_sc_hd__decap_12
XFILLER_0_218_979 VGND VGND VPWR VPWR sky130_fd_sc_hd__fill_1
XFILLER_0_205_629 VPWR VGND VPWR VGND sky130_ef_sc_hd__decap_12
XFILLER_0_217_55 VGND VGND VPWR VPWR sky130_fd_sc_hd__fill_1
XFILLER_0_38_1201 VPWR VGND VPWR VGND sky130_ef_sc_hd__decap_12
XTAP_2420 VGND VPWR sky130_fd_sc_hd__tapvpwrvgnd_1
XTAP_2453 VGND VPWR sky130_fd_sc_hd__tapvpwrvgnd_1
XTAP_2431 VGND VPWR sky130_fd_sc_hd__tapvpwrvgnd_1
XFILLER_0_213_673 VPWR VGND VPWR VGND sky130_ef_sc_hd__decap_12
XTAP_2442 VGND VPWR sky130_fd_sc_hd__tapvpwrvgnd_1
XTAP_2475 VGND VPWR sky130_fd_sc_hd__tapvpwrvgnd_1
XTAP_2464 VGND VPWR sky130_fd_sc_hd__tapvpwrvgnd_1
XTAP_2486 VGND VPWR sky130_fd_sc_hd__tapvpwrvgnd_1
XFILLER_0_150_1337 VGND VGND VPWR VPWR sky130_fd_sc_hd__fill_1
XTAP_1741 VGND VPWR sky130_fd_sc_hd__tapvpwrvgnd_1
XTAP_1730 VGND VPWR sky130_fd_sc_hd__tapvpwrvgnd_1
XTAP_1752 VGND VPWR sky130_fd_sc_hd__tapvpwrvgnd_1
XTAP_2497 VGND VPWR sky130_fd_sc_hd__tapvpwrvgnd_1
XTAP_1785 VGND VPWR sky130_fd_sc_hd__tapvpwrvgnd_1
XTAP_1763 VGND VPWR sky130_fd_sc_hd__tapvpwrvgnd_1
XTAP_1774 VGND VPWR sky130_fd_sc_hd__tapvpwrvgnd_1
XTAP_1796 VGND VPWR sky130_fd_sc_hd__tapvpwrvgnd_1
XFILLER_0_114_809 VGND VGND VPWR VPWR sky130_fd_sc_hd__decap_3
XFILLER_0_3_1287 VGND VGND VPWR VPWR sky130_fd_sc_hd__fill_1
XFILLER_0_141_617 VPWR VGND VPWR VGND sky130_ef_sc_hd__decap_12
XFILLER_0_3_517 VPWR VGND VPWR VGND sky130_ef_sc_hd__decap_12
XFILLER_0_178_29 VPWR VGND VPWR VGND sky130_ef_sc_hd__decap_12
XFILLER_0_45_1249 VGND VGND VPWR VPWR sky130_fd_sc_hd__decap_4
XFILLER_0_220_1029 VGND VGND VPWR VPWR sky130_fd_sc_hd__decap_6
XFILLER_0_224_905 VPWR VGND VPWR VGND sky130_ef_sc_hd__decap_12
XFILLER_0_194_1275 VGND VGND VPWR VPWR sky130_fd_sc_hd__decap_6
XFILLER_0_224_949 VPWR VGND VPWR VGND sky130_ef_sc_hd__decap_12
XFILLER_0_155_1237 VPWR VGND VPWR VGND sky130_ef_sc_hd__decap_12
Xinput5 act_row0_in[13] VGND VGND VPWR VPWR net5 sky130_fd_sc_hd__clkbuf_4
XFILLER_0_91_1225 VPWR VGND VPWR VGND sky130_ef_sc_hd__decap_12
XFILLER_0_143_10 VPWR VGND VPWR VGND sky130_ef_sc_hd__decap_12
XFILLER_0_52_41 VGND VGND VPWR VPWR sky130_fd_sc_hd__decap_8
XFILLER_0_4_1029 VGND VGND VPWR VPWR sky130_fd_sc_hd__decap_6
XFILLER_0_117_647 VPWR VGND VPWR VGND sky130_ef_sc_hd__decap_12
XFILLER_0_105_809 VPWR VGND VPWR VGND sky130_ef_sc_hd__decap_12
XFILLER_0_6_333 VPWR VGND VPWR VGND sky130_ef_sc_hd__decap_12
XFILLER_0_132_617 VGND VGND VPWR VPWR sky130_fd_sc_hd__fill_1
XFILLER_0_6_377 VPWR VGND VPWR VGND sky130_ef_sc_hd__decap_12
XFILLER_0_15_645 VGND VGND VPWR VPWR sky130_fd_sc_hd__fill_1
XFILLER_0_113_853 VPWR VGND VPWR VGND sky130_ef_sc_hd__decap_12
XFILLER_0_72_3 VPWR VGND VPWR VGND sky130_ef_sc_hd__decap_12
XFILLER_0_218_209 VPWR VGND VPWR VGND sky130_ef_sc_hd__decap_12
XANTENNA_u_pe01_weight_in[13] net121 VGND VGND VPWR VPWR sky130_fd_sc_hd__diode_2
XFILLER_0_113_897 VPWR VGND VPWR VGND sky130_ef_sc_hd__decap_12
XFILLER_0_112_363 VGND VGND VPWR VPWR sky130_fd_sc_hd__fill_1
XFILLER_0_203_1249 VGND VGND VPWR VPWR sky130_fd_sc_hd__decap_4
XFILLER_0_226_253 VPWR VGND VPWR VGND sky130_ef_sc_hd__decap_12
XFILLER_0_199_617 VPWR VGND VPWR VGND sky130_ef_sc_hd__decap_12
XPHY_802 VGND VGND VPWR VPWR sky130_fd_sc_hd__decap_3
XFILLER_0_203_13 VPWR VGND VPWR VGND sky130_ef_sc_hd__decap_12
XPHY_835 VGND VGND VPWR VPWR sky130_fd_sc_hd__decap_3
XPHY_813 VGND VGND VPWR VPWR sky130_fd_sc_hd__decap_3
XPHY_824 VGND VGND VPWR VPWR sky130_fd_sc_hd__decap_3
XFILLER_0_212_1091 VGND VGND VPWR VPWR sky130_fd_sc_hd__fill_1
XPHY_846 VGND VGND VPWR VPWR sky130_fd_sc_hd__decap_3
XPHY_868 VGND VGND VPWR VPWR sky130_fd_sc_hd__decap_3
XPHY_857 VGND VGND VPWR VPWR sky130_fd_sc_hd__decap_3
XFILLER_0_108_625 VPWR VGND VPWR VGND sky130_ef_sc_hd__decap_12
XPHY_879 VGND VGND VPWR VPWR sky130_fd_sc_hd__decap_3
XFILLER_0_108_669 VPWR VGND VPWR VGND sky130_ef_sc_hd__decap_12
XFILLER_0_68_1227 VPWR VGND VPWR VGND sky130_ef_sc_hd__decap_12
XFILLER_0_107_113 VPWR VGND VPWR VGND sky130_ef_sc_hd__decap_12
XFILLER_0_123_617 VPWR VGND VPWR VGND sky130_ef_sc_hd__decap_12
XFILLER_0_180_1319 VPWR VGND VPWR VGND sky130_ef_sc_hd__decap_12
XFILLER_0_104_853 VPWR VGND VPWR VGND sky130_ef_sc_hd__decap_12
XFILLER_0_108_1261 VPWR VGND VPWR VGND sky130_ef_sc_hd__decap_12
XFILLER_0_104_897 VPWR VGND VPWR VGND sky130_ef_sc_hd__decap_12
XANTENNA_input56_A psum_col0_in[2] VGND VGND VPWR VPWR sky130_fd_sc_hd__diode_2
XFILLER_0_79_1323 VPWR VGND VPWR VGND sky130_ef_sc_hd__decap_12
XFILLER_0_219_1201 VPWR VGND VPWR VGND sky130_ef_sc_hd__decap_12
XFILLER_0_219_1245 VPWR VGND VPWR VGND sky130_ef_sc_hd__decap_12
XFILLER_0_219_1289 VPWR VGND VPWR VGND sky130_ef_sc_hd__decap_12
XFILLER_0_214_993 VPWR VGND VPWR VGND sky130_ef_sc_hd__decap_12
XANTENNA_output212_A net212 VGND VGND VPWR VPWR sky130_fd_sc_hd__diode_2
XFILLER_0_154_1281 VGND VGND VPWR VPWR sky130_fd_sc_hd__fill_1
XTAP_2261 VGND VPWR sky130_fd_sc_hd__tapvpwrvgnd_1
XTAP_2250 VGND VPWR sky130_fd_sc_hd__tapvpwrvgnd_1
XFILLER_0_189_1311 VPWR VGND VPWR VGND sky130_ef_sc_hd__decap_12
XTAP_2283 VGND VPWR sky130_fd_sc_hd__tapvpwrvgnd_1
XTAP_2272 VGND VPWR sky130_fd_sc_hd__tapvpwrvgnd_1
XTAP_2294 VGND VPWR sky130_fd_sc_hd__tapvpwrvgnd_1
XTAP_1560 VGND VPWR sky130_fd_sc_hd__tapvpwrvgnd_1
XTAP_1582 VGND VPWR sky130_fd_sc_hd__tapvpwrvgnd_1
XTAP_1571 VGND VPWR sky130_fd_sc_hd__tapvpwrvgnd_1
XTAP_1593 VGND VPWR sky130_fd_sc_hd__tapvpwrvgnd_1
XFILLER_0_51_1253 VGND VGND VPWR VPWR sky130_fd_sc_hd__fill_1
XFILLER_0_113_57 VPWR VGND VPWR VGND sky130_ef_sc_hd__decap_12
XFILLER_0_226_1216 VGND VGND VPWR VPWR sky130_fd_sc_hd__fill_2
XFILLER_0_226_1205 VGND VGND VPWR VPWR sky130_fd_sc_hd__fill_1
XFILLER_0_114_617 VPWR VGND VPWR VGND sky130_ef_sc_hd__decap_12
XFILLER_0_4_837 VPWR VGND VPWR VGND sky130_ef_sc_hd__decap_12
XFILLER_0_113_105 VGND VGND VPWR VPWR sky130_fd_sc_hd__decap_6
XFILLER_0_113_149 VPWR VGND VPWR VGND sky130_ef_sc_hd__decap_12
XFILLER_0_122_1225 VGND VGND VPWR VPWR sky130_fd_sc_hd__fill_1
XFILLER_0_110_867 VGND VGND VPWR VPWR sky130_fd_sc_hd__fill_1
XFILLER_0_23_1311 VPWR VGND VPWR VGND sky130_ef_sc_hd__decap_12
XFILLER_0_196_1337 VGND VGND VPWR VPWR sky130_fd_sc_hd__fill_1
XFILLER_0_224_713 VPWR VGND VPWR VGND sky130_ef_sc_hd__decap_12
XFILLER_0_224_757 VPWR VGND VPWR VGND sky130_ef_sc_hd__decap_12
XFILLER_0_223_223 VGND VGND VPWR VPWR sky130_fd_sc_hd__fill_1
XFILLER_0_93_1309 VGND VGND VPWR VPWR sky130_fd_sc_hd__fill_1
XFILLER_0_211_429 VPWR VGND VPWR VGND sky130_ef_sc_hd__decap_12
XFILLER_0_2_65 VPWR VGND VPWR VGND sky130_ef_sc_hd__decap_12
XFILLER_0_133_1343 VGND VGND VPWR VPWR sky130_fd_sc_hd__fill_1
XPHY_109 VGND VGND VPWR VPWR sky130_fd_sc_hd__decap_3
XFILLER_0_170_41 VGND VGND VPWR VPWR sky130_fd_sc_hd__decap_8
XFILLER_0_30_1337 VGND VGND VPWR VPWR sky130_fd_sc_hd__fill_1
XFILLER_0_105_617 VPWR VGND VPWR VGND sky130_ef_sc_hd__decap_12
XFILLER_0_6_141 VPWR VGND VPWR VGND sky130_ef_sc_hd__decap_12
XFILLER_0_7_697 VGND VGND VPWR VPWR sky130_fd_sc_hd__decap_3
XFILLER_0_219_529 VPWR VGND VPWR VGND sky130_ef_sc_hd__decap_12
XFILLER_0_101_1309 VGND VGND VPWR VPWR sky130_fd_sc_hd__fill_1
Xoutput183 net183 VGND VGND VPWR VPWR psum_col0_out[26] sky130_fd_sc_hd__clkbuf_4
Xoutput194 net194 VGND VGND VPWR VPWR psum_col0_out[7] sky130_fd_sc_hd__clkbuf_4
Xoutput172 net172 VGND VGND VPWR VPWR psum_col0_out[16] sky130_fd_sc_hd__clkbuf_4
XFILLER_0_214_245 VGND VGND VPWR VPWR sky130_fd_sc_hd__decap_6
XFILLER_0_214_289 VPWR VGND VPWR VGND sky130_ef_sc_hd__decap_12
XFILLER_0_35_1237 VPWR VGND VPWR VGND sky130_ef_sc_hd__decap_12
XFILLER_0_74_1275 VGND VGND VPWR VPWR sky130_fd_sc_hd__decap_6
XANTENNA_input110_A w00[3] VGND VGND VPWR VPWR sky130_fd_sc_hd__diode_2
XANTENNA_u_pe11_weight_in[1] net156 VGND VGND VPWR VPWR sky130_fd_sc_hd__diode_2
XFILLER_0_85_629 VPWR VGND VPWR VGND sky130_ef_sc_hd__decap_12
XPHY_610 VGND VGND VPWR VPWR sky130_fd_sc_hd__decap_3
XFILLER_0_214_1197 VGND VGND VPWR VPWR sky130_fd_sc_hd__decap_6
XFILLER_0_210_473 VGND VGND VPWR VPWR sky130_fd_sc_hd__decap_3
XPHY_643 VGND VGND VPWR VPWR sky130_fd_sc_hd__decap_3
XPHY_621 VGND VGND VPWR VPWR sky130_fd_sc_hd__decap_3
XPHY_632 VGND VGND VPWR VPWR sky130_fd_sc_hd__decap_3
XPHY_654 VGND VGND VPWR VPWR sky130_fd_sc_hd__decap_3
XPHY_676 VGND VGND VPWR VPWR sky130_fd_sc_hd__decap_3
XPHY_665 VGND VGND VPWR VPWR sky130_fd_sc_hd__decap_3
XFILLER_0_109_945 VGND VGND VPWR VPWR sky130_fd_sc_hd__decap_6
XFILLER_0_108_433 VPWR VGND VPWR VGND sky130_ef_sc_hd__decap_12
XPHY_687 VGND VGND VPWR VPWR sky130_fd_sc_hd__decap_3
XFILLER_0_110_1173 VPWR VGND VPWR VGND sky130_ef_sc_hd__decap_12
XFILLER_0_109_989 VPWR VGND VPWR VGND sky130_ef_sc_hd__decap_12
XFILLER_0_108_477 VPWR VGND VPWR VGND sky130_ef_sc_hd__decap_12
XPHY_698 VGND VGND VPWR VPWR sky130_fd_sc_hd__decap_3
XFILLER_0_184_1263 VPWR VGND VPWR VGND sky130_ef_sc_hd__decap_12
XFILLER_0_0_1257 VGND VGND VPWR VPWR sky130_fd_sc_hd__fill_1
XFILLER_0_145_1225 VPWR VGND VPWR VGND sky130_ef_sc_hd__decap_12
XFILLER_0_111_609 VGND VGND VPWR VPWR sky130_fd_sc_hd__decap_6
XFILLER_0_81_1213 VPWR VGND VPWR VGND sky130_ef_sc_hd__decap_12
XFILLER_0_221_1113 VGND VGND VPWR VPWR sky130_fd_sc_hd__decap_6
XFILLER_0_68_29 VPWR VGND VPWR VGND sky130_ef_sc_hd__decap_12
XFILLER_0_0_317 VPWR VGND VPWR VGND sky130_ef_sc_hd__decap_12
XFILLER_0_108_1091 VGND VGND VPWR VPWR sky130_fd_sc_hd__fill_1
XFILLER_0_81_1279 VPWR VGND VPWR VGND sky130_ef_sc_hd__decap_12
XFILLER_0_221_1157 VPWR VGND VPWR VGND sky130_ef_sc_hd__decap_12
XFILLER_0_121_1291 VPWR VGND VPWR VGND sky130_ef_sc_hd__decap_12
XFILLER_0_191_1201 VPWR VGND VPWR VGND sky130_ef_sc_hd__decap_12
XFILLER_0_156_1343 VGND VGND VPWR VPWR sky130_fd_sc_hd__fill_1
XFILLER_0_191_1267 VPWR VGND VPWR VGND sky130_ef_sc_hd__decap_12
XFILLER_0_221_727 VGND VGND VPWR VPWR sky130_fd_sc_hd__fill_1
XFILLER_0_92_1331 VGND VGND VPWR VPWR sky130_fd_sc_hd__decap_6
XFILLER_0_186_631 VPWR VGND VPWR VGND sky130_ef_sc_hd__decap_12
XFILLER_0_5_1113 VGND VGND VPWR VPWR sky130_fd_sc_hd__decap_6
XTAP_2091 VGND VPWR sky130_fd_sc_hd__tapvpwrvgnd_1
XTAP_2080 VGND VPWR sky130_fd_sc_hd__tapvpwrvgnd_1
XFILLER_0_5_1157 VPWR VGND VPWR VGND sky130_ef_sc_hd__decap_12
XFILLER_0_130_3 VPWR VGND VPWR VGND sky130_ef_sc_hd__decap_12
XTAP_1390 VGND VPWR sky130_fd_sc_hd__tapvpwrvgnd_1
XFILLER_0_4_601 VPWR VGND VPWR VGND sky130_ef_sc_hd__decap_12
XFILLER_0_140_22 VGND VGND VPWR VPWR sky130_fd_sc_hd__decap_6
XFILLER_0_163_1303 VGND VGND VPWR VPWR sky130_fd_sc_hd__decap_6
Xinput30 act_row1_in[7] VGND VGND VPWR VPWR net30 sky130_fd_sc_hd__buf_1
XFILLER_0_3_111 VGND VGND VPWR VPWR sky130_fd_sc_hd__fill_1
Xinput52 psum_col0_in[26] VGND VGND VPWR VPWR net52 sky130_fd_sc_hd__buf_1
Xinput41 psum_col0_in[16] VGND VGND VPWR VPWR net41 sky130_fd_sc_hd__buf_1
Xinput63 psum_col0_in[7] VGND VGND VPWR VPWR net63 sky130_fd_sc_hd__buf_1
XFILLER_0_4_645 VPWR VGND VPWR VGND sky130_ef_sc_hd__decap_12
Xinput85 psum_col1_in[27] VGND VGND VPWR VPWR net85 sky130_fd_sc_hd__dlymetal6s2s_1
Xinput74 psum_col1_in[17] VGND VGND VPWR VPWR net74 sky130_fd_sc_hd__buf_1
Xinput96 psum_col1_in[8] VGND VGND VPWR VPWR net96 sky130_fd_sc_hd__buf_1
XFILLER_0_60_1319 VPWR VGND VPWR VGND sky130_ef_sc_hd__decap_12
XFILLER_0_0_895 VGND VGND VPWR VPWR sky130_fd_sc_hd__fill_1
XFILLER_0_100_1331 VGND VGND VPWR VPWR sky130_fd_sc_hd__decap_6
XFILLER_0_97_1253 VGND VGND VPWR VPWR sky130_fd_sc_hd__fill_1
XFILLER_0_224_587 VGND VGND VPWR VPWR sky130_fd_sc_hd__fill_1
XFILLER_0_170_1307 VPWR VGND VPWR VGND sky130_ef_sc_hd__decap_12
XFILLER_0_212_749 VGND VGND VPWR VPWR sky130_fd_sc_hd__decap_6
XFILLER_0_211_237 VPWR VGND VPWR VGND sky130_ef_sc_hd__decap_12
XFILLER_0_67_629 VPWR VGND VPWR VGND sky130_ef_sc_hd__decap_12
XFILLER_0_211_1337 VGND VGND VPWR VPWR sky130_fd_sc_hd__decap_6
XFILLER_0_220_793 VPWR VGND VPWR VGND sky130_ef_sc_hd__decap_12
XFILLER_0_168_1225 VGND VGND VPWR VPWR sky130_fd_sc_hd__fill_1
XFILLER_0_34_1281 VGND VGND VPWR VPWR sky130_fd_sc_hd__fill_1
XFILLER_0_69_1311 VPWR VGND VPWR VGND sky130_ef_sc_hd__decap_12
XFILLER_0_90_643 VPWR VGND VPWR VGND sky130_ef_sc_hd__decap_12
XFILLER_0_106_937 VPWR VGND VPWR VGND sky130_ef_sc_hd__decap_12
XFILLER_0_7_461 VPWR VGND VPWR VGND sky130_ef_sc_hd__decap_12
XFILLER_0_209_1255 VPWR VGND VPWR VGND sky130_ef_sc_hd__decap_12
XFILLER_0_105_447 VGND VGND VPWR VPWR sky130_fd_sc_hd__fill_1
XFILLER_0_114_981 VPWR VGND VPWR VGND sky130_ef_sc_hd__decap_12
XFILLER_0_105_1231 VGND VGND VPWR VPWR sky130_fd_sc_hd__fill_1
XFILLER_0_219_337 VPWR VGND VPWR VGND sky130_ef_sc_hd__decap_12
XANTENNA_input158_A w11[3] VGND VGND VPWR VPWR sky130_fd_sc_hd__diode_2
XFILLER_0_76_1337 VGND VGND VPWR VPWR sky130_fd_sc_hd__fill_1
XFILLER_0_225_22 VPWR VGND VPWR VGND sky130_ef_sc_hd__decap_12
XANTENNA_input19_A act_row1_in[11] VGND VGND VPWR VPWR sky130_fd_sc_hd__diode_2
XFILLER_0_216_1259 VGND VGND VPWR VPWR sky130_fd_sc_hd__fill_1
XFILLER_0_168_631 VPWR VGND VPWR VGND sky130_ef_sc_hd__decap_12
XFILLER_0_210_281 VPWR VGND VPWR VGND sky130_ef_sc_hd__decap_12
XFILLER_0_183_645 VGND VGND VPWR VPWR sky130_fd_sc_hd__fill_1
XPHY_462 VGND VGND VPWR VPWR sky130_fd_sc_hd__decap_3
XPHY_451 VGND VGND VPWR VPWR sky130_fd_sc_hd__decap_3
XFILLER_0_13_1343 VGND VGND VPWR VPWR sky130_fd_sc_hd__fill_1
XPHY_440 VGND VGND VPWR VPWR sky130_fd_sc_hd__decap_3
XPHY_1050 VGND VGND VPWR VPWR sky130_fd_sc_hd__decap_3
XFILLER_0_147_1309 VGND VGND VPWR VPWR sky130_fd_sc_hd__fill_1
XFILLER_0_109_753 VPWR VGND VPWR VGND sky130_ef_sc_hd__decap_12
XPHY_473 VGND VGND VPWR VPWR sky130_fd_sc_hd__decap_3
XPHY_484 VGND VGND VPWR VPWR sky130_fd_sc_hd__decap_3
XFILLER_0_0_1021 VPWR VGND VPWR VGND sky130_ef_sc_hd__decap_12
XPHY_495 VGND VGND VPWR VPWR sky130_fd_sc_hd__decap_3
XPHY_1072 VGND VGND VPWR VPWR sky130_fd_sc_hd__decap_3
XPHY_1061 VGND VGND VPWR VPWR sky130_fd_sc_hd__decap_3
XPHY_1083 VGND VGND VPWR VPWR sky130_fd_sc_hd__decap_3
XFILLER_0_109_797 VPWR VGND VPWR VGND sky130_ef_sc_hd__decap_12
XFILLER_0_0_1043 VPWR VGND VPWR VGND sky130_ef_sc_hd__decap_12
XPHY_1094 VGND VGND VPWR VPWR sky130_fd_sc_hd__decap_3
XFILLER_0_79_39 VGND VGND VPWR VPWR sky130_fd_sc_hd__decap_8
XFILLER_0_0_1087 VGND VGND VPWR VPWR sky130_fd_sc_hd__decap_4
XFILLER_0_106_1017 VPWR VGND VPWR VGND sky130_ef_sc_hd__decap_12
XFILLER_0_1_615 VGND VGND VPWR VPWR sky130_fd_sc_hd__fill_1
XFILLER_0_111_417 VPWR VGND VPWR VGND sky130_ef_sc_hd__decap_12
XFILLER_0_186_29 VPWR VGND VPWR VGND sky130_ef_sc_hd__decap_12
XFILLER_0_0_169 VGND VGND VPWR VPWR sky130_fd_sc_hd__decap_8
XFILLER_0_0_147 VGND VGND VPWR VPWR sky130_fd_sc_hd__decap_8
XFILLER_0_95_27 VPWR VGND VPWR VGND sky130_ef_sc_hd__decap_12
XFILLER_0_119_34 VPWR VGND VPWR VGND sky130_ef_sc_hd__decap_12
XFILLER_0_225_329 VGND VGND VPWR VPWR sky130_fd_sc_hd__decap_6
XANTENNA_u_pe00_psum_in[3] net59 VGND VGND VPWR VPWR sky130_fd_sc_hd__diode_2
XFILLER_0_21_9 VGND VGND VPWR VPWR sky130_fd_sc_hd__fill_2
XFILLER_0_49_629 VPWR VGND VPWR VGND sky130_ef_sc_hd__decap_12
XFILLER_0_60_41 VGND VGND VPWR VPWR sky130_fd_sc_hd__decap_8
XFILLER_0_5_921 VPWR VGND VPWR VGND sky130_ef_sc_hd__decap_12
XFILLER_0_72_643 VPWR VGND VPWR VGND sky130_ef_sc_hd__decap_12
XFILLER_0_167_1291 VPWR VGND VPWR VGND sky130_ef_sc_hd__decap_12
XFILLER_0_5_965 VPWR VGND VPWR VGND sky130_ef_sc_hd__decap_12
XFILLER_0_128_1275 VGND VGND VPWR VPWR sky130_fd_sc_hd__decap_6
XFILLER_0_4_475 VGND VGND VPWR VPWR sky130_fd_sc_hd__fill_1
XFILLER_0_114_277 VGND VGND VPWR VPWR sky130_fd_sc_hd__decap_3
XFILLER_0_25_1225 VPWR VGND VPWR VGND sky130_ef_sc_hd__decap_12
XFILLER_0_64_1263 VPWR VGND VPWR VGND sky130_ef_sc_hd__decap_12
XFILLER_0_111_951 VGND VGND VPWR VPWR sky130_fd_sc_hd__fill_1
XFILLER_0_216_307 VGND VGND VPWR VPWR sky130_fd_sc_hd__fill_1
XFILLER_0_225_841 VPWR VGND VPWR VGND sky130_ef_sc_hd__decap_12
XFILLER_0_212_513 VPWR VGND VPWR VGND sky130_ef_sc_hd__decap_12
XFILLER_0_174_1251 VPWR VGND VPWR VGND sky130_ef_sc_hd__decap_12
XTAP_2816 VGND VPWR sky130_fd_sc_hd__tapvpwrvgnd_1
XTAP_2827 VGND VPWR sky130_fd_sc_hd__tapvpwrvgnd_1
XTAP_2805 VGND VPWR sky130_fd_sc_hd__tapvpwrvgnd_1
XFILLER_0_135_1213 VPWR VGND VPWR VGND sky130_ef_sc_hd__decap_12
XANTENNA_u_pe11_act_in[7] act_10_out_11_in\[7\] VGND VGND VPWR VPWR sky130_fd_sc_hd__diode_2
XFILLER_0_71_1201 VPWR VGND VPWR VGND sky130_ef_sc_hd__decap_12
XTAP_2849 VGND VPWR sky130_fd_sc_hd__tapvpwrvgnd_1
XTAP_2838 VGND VPWR sky130_fd_sc_hd__tapvpwrvgnd_1
XFILLER_0_212_557 VPWR VGND VPWR VGND sky130_ef_sc_hd__decap_12
XFILLER_0_174_1295 VPWR VGND VPWR VGND sky130_ef_sc_hd__decap_12
XFILLER_0_135_1279 VPWR VGND VPWR VGND sky130_ef_sc_hd__decap_12
XFILLER_0_36_1343 VGND VGND VPWR VPWR sky130_fd_sc_hd__fill_1
XFILLER_0_215_1281 VGND VGND VPWR VPWR sky130_fd_sc_hd__decap_6
XFILLER_0_211_1101 VPWR VGND VPWR VGND sky130_ef_sc_hd__decap_12
XFILLER_0_71_1267 VPWR VGND VPWR VGND sky130_ef_sc_hd__decap_12
XFILLER_0_211_1145 VPWR VGND VPWR VGND sky130_ef_sc_hd__decap_12
XFILLER_0_165_645 VGND VGND VPWR VPWR sky130_fd_sc_hd__fill_1
XFILLER_0_211_1189 VPWR VGND VPWR VGND sky130_ef_sc_hd__decap_12
XFILLER_0_106_701 VPWR VGND VPWR VGND sky130_ef_sc_hd__decap_12
XFILLER_0_211_57 VPWR VGND VPWR VGND sky130_ef_sc_hd__decap_12
XFILLER_0_146_1331 VGND VGND VPWR VPWR sky130_fd_sc_hd__decap_6
XFILLER_0_181_1255 VPWR VGND VPWR VGND sky130_ef_sc_hd__decap_12
XFILLER_0_142_1239 VPWR VGND VPWR VGND sky130_ef_sc_hd__decap_12
XFILLER_0_43_1303 VGND VGND VPWR VPWR sky130_fd_sc_hd__decap_6
XFILLER_0_222_1241 VPWR VGND VPWR VGND sky130_ef_sc_hd__decap_12
XFILLER_0_222_1285 VPWR VGND VPWR VGND sky130_ef_sc_hd__decap_12
XFILLER_0_219_167 VGND VGND VPWR VPWR sky130_fd_sc_hd__fill_1
XFILLER_0_215_373 VPWR VGND VPWR VGND sky130_ef_sc_hd__decap_12
XFILLER_0_153_1335 VGND VGND VPWR VPWR sky130_fd_sc_hd__decap_8
XFILLER_0_6_1241 VPWR VGND VPWR VGND sky130_ef_sc_hd__decap_12
XFILLER_0_50_1307 VPWR VGND VPWR VGND sky130_ef_sc_hd__decap_12
XFILLER_0_2_1105 VPWR VGND VPWR VGND sky130_ef_sc_hd__decap_12
XFILLER_0_105_69 VPWR VGND VPWR VGND sky130_ef_sc_hd__decap_12
XPHY_270 VGND VGND VPWR VPWR sky130_fd_sc_hd__decap_3
XFILLER_0_6_1285 VPWR VGND VPWR VGND sky130_ef_sc_hd__decap_12
XFILLER_0_109_561 VPWR VGND VPWR VGND sky130_ef_sc_hd__decap_12
XPHY_292 VGND VGND VPWR VPWR sky130_fd_sc_hd__decap_3
XPHY_281 VGND VGND VPWR VPWR sky130_fd_sc_hd__decap_3
XFILLER_0_5_217 VGND VGND VPWR VPWR sky130_fd_sc_hd__decap_6
XFILLER_0_54_643 VPWR VGND VPWR VGND sky130_ef_sc_hd__decap_12
XFILLER_0_2_1149 VPWR VGND VPWR VGND sky130_ef_sc_hd__decap_12
XFILLER_0_48_1225 VGND VGND VPWR VPWR sky130_fd_sc_hd__fill_1
XFILLER_0_197_39 VGND VGND VPWR VPWR sky130_fd_sc_hd__decap_8
XFILLER_0_112_737 VPWR VGND VPWR VGND sky130_ef_sc_hd__decap_12
XFILLER_0_111_225 VPWR VGND VPWR VGND sky130_ef_sc_hd__decap_12
XFILLER_0_201_1303 VGND VGND VPWR VPWR sky130_fd_sc_hd__decap_6
XFILLER_0_160_1339 VGND VGND VPWR VPWR sky130_fd_sc_hd__decap_4
XFILLER_0_2_979 VGND VGND VPWR VPWR sky130_fd_sc_hd__fill_1
XFILLER_0_226_638 VGND VGND VPWR VPWR sky130_fd_sc_hd__fill_1
XFILLER_0_158_1213 VPWR VGND VPWR VGND sky130_ef_sc_hd__decap_12
XFILLER_0_225_137 VPWR VGND VPWR VGND sky130_ef_sc_hd__decap_12
XFILLER_0_94_1201 VPWR VGND VPWR VGND sky130_ef_sc_hd__decap_12
XFILLER_0_222_811 VGND VGND VPWR VPWR sky130_fd_sc_hd__fill_1
XFILLER_0_7_1005 VGND VGND VPWR VPWR sky130_fd_sc_hd__decap_3
XFILLER_0_7_1049 VPWR VGND VPWR VGND sky130_ef_sc_hd__decap_12
XFILLER_0_147_645 VGND VGND VPWR VPWR sky130_fd_sc_hd__fill_1
XFILLER_0_27_1309 VGND VGND VPWR VPWR sky130_fd_sc_hd__fill_1
XFILLER_0_206_1225 VGND VGND VPWR VPWR sky130_fd_sc_hd__fill_1
XFILLER_0_102_1201 VPWR VGND VPWR VGND sky130_ef_sc_hd__decap_12
XFILLER_0_225_671 VGND VGND VPWR VPWR sky130_fd_sc_hd__fill_1
XFILLER_0_217_1343 VGND VGND VPWR VPWR sky130_fd_sc_hd__fill_1
XFILLER_0_213_833 VGND VGND VPWR VPWR sky130_fd_sc_hd__decap_6
XTAP_2602 VGND VPWR sky130_fd_sc_hd__tapvpwrvgnd_1
XFILLER_0_212_321 VPWR VGND VPWR VGND sky130_ef_sc_hd__decap_12
XFILLER_0_206_13 VPWR VGND VPWR VGND sky130_ef_sc_hd__decap_12
XTAP_2613 VGND VPWR sky130_fd_sc_hd__tapvpwrvgnd_1
XTAP_2635 VGND VPWR sky130_fd_sc_hd__tapvpwrvgnd_1
XFILLER_0_213_877 VPWR VGND VPWR VGND sky130_ef_sc_hd__decap_12
XTAP_2624 VGND VPWR sky130_fd_sc_hd__tapvpwrvgnd_1
XFILLER_0_212_365 VPWR VGND VPWR VGND sky130_ef_sc_hd__decap_12
XTAP_1901 VGND VPWR sky130_fd_sc_hd__tapvpwrvgnd_1
XTAP_2657 VGND VPWR sky130_fd_sc_hd__tapvpwrvgnd_1
XTAP_2679 VGND VPWR sky130_fd_sc_hd__tapvpwrvgnd_1
XTAP_2668 VGND VPWR sky130_fd_sc_hd__tapvpwrvgnd_1
XTAP_2646 VGND VPWR sky130_fd_sc_hd__tapvpwrvgnd_1
XTAP_1923 VGND VPWR sky130_fd_sc_hd__tapvpwrvgnd_1
XTAP_1934 VGND VPWR sky130_fd_sc_hd__tapvpwrvgnd_1
XTAP_1912 VGND VPWR sky130_fd_sc_hd__tapvpwrvgnd_1
XTAP_1967 VGND VPWR sky130_fd_sc_hd__tapvpwrvgnd_1
XTAP_1945 VGND VPWR sky130_fd_sc_hd__tapvpwrvgnd_1
XTAP_1956 VGND VPWR sky130_fd_sc_hd__tapvpwrvgnd_1
XTAP_1989 VGND VPWR sky130_fd_sc_hd__tapvpwrvgnd_1
XTAP_1978 VGND VPWR sky130_fd_sc_hd__tapvpwrvgnd_1
XFILLER_0_36_643 VPWR VGND VPWR VGND sky130_ef_sc_hd__decap_12
XANTENNA_input86_A psum_col1_in[28] VGND VGND VPWR VPWR sky130_fd_sc_hd__diode_2
XFILLER_0_106_531 VGND VGND VPWR VPWR sky130_fd_sc_hd__fill_1
XFILLER_0_2_209 VPWR VGND VPWR VGND sky130_ef_sc_hd__decap_12
XFILLER_0_107_1101 VPWR VGND VPWR VGND sky130_ef_sc_hd__decap_12
XFILLER_0_107_1145 VPWR VGND VPWR VGND sky130_ef_sc_hd__decap_12
XFILLER_0_47_1291 VPWR VGND VPWR VGND sky130_ef_sc_hd__decap_12
XFILLER_0_208_605 VPWR VGND VPWR VGND sky130_ef_sc_hd__decap_12
XFILLER_0_107_1189 VPWR VGND VPWR VGND sky130_ef_sc_hd__decap_12
XFILLER_0_76_29 VPWR VGND VPWR VGND sky130_ef_sc_hd__decap_12
XFILLER_0_222_1093 VPWR VGND VPWR VGND sky130_ef_sc_hd__decap_12
XFILLER_0_218_1129 VPWR VGND VPWR VGND sky130_ef_sc_hd__decap_12
XFILLER_0_216_693 VGND VGND VPWR VPWR sky130_fd_sc_hd__decap_6
XFILLER_0_215_181 VPWR VGND VPWR VGND sky130_ef_sc_hd__decap_12
XFILLER_0_118_1263 VPWR VGND VPWR VGND sky130_ef_sc_hd__decap_12
XFILLER_0_114_1105 VPWR VGND VPWR VGND sky130_ef_sc_hd__decap_12
XFILLER_0_54_1251 VPWR VGND VPWR VGND sky130_ef_sc_hd__decap_12
XFILLER_0_114_1149 VPWR VGND VPWR VGND sky130_ef_sc_hd__decap_12
XFILLER_0_89_1303 VGND VGND VPWR VPWR sky130_fd_sc_hd__decap_6
XFILLER_0_15_1213 VPWR VGND VPWR VGND sky130_ef_sc_hd__decap_12
XFILLER_0_54_1295 VPWR VGND VPWR VGND sky130_ef_sc_hd__decap_12
XFILLER_0_188_1239 VPWR VGND VPWR VGND sky130_ef_sc_hd__decap_12
XFILLER_0_129_645 VGND VGND VPWR VPWR sky130_fd_sc_hd__fill_1
XFILLER_0_15_1279 VPWR VGND VPWR VGND sky130_ef_sc_hd__decap_12
XFILLER_0_6_1093 VPWR VGND VPWR VGND sky130_ef_sc_hd__decap_12
XFILLER_0_109_391 VGND VGND VPWR VPWR sky130_fd_sc_hd__fill_1
XFILLER_0_112_501 VPWR VGND VPWR VGND sky130_ef_sc_hd__decap_12
XFILLER_0_125_1201 VPWR VGND VPWR VGND sky130_ef_sc_hd__decap_12
XFILLER_0_164_1283 VPWR VGND VPWR VGND sky130_ef_sc_hd__decap_12
XFILLER_0_112_545 VPWR VGND VPWR VGND sky130_ef_sc_hd__decap_12
XFILLER_0_26_1331 VGND VGND VPWR VPWR sky130_fd_sc_hd__decap_6
XFILLER_0_199_1335 VGND VGND VPWR VPWR sky130_fd_sc_hd__decap_8
XFILLER_0_125_1267 VPWR VGND VPWR VGND sky130_ef_sc_hd__decap_12
XFILLER_0_112_589 VPWR VGND VPWR VGND sky130_ef_sc_hd__decap_12
XFILLER_0_61_1255 VPWR VGND VPWR VGND sky130_ef_sc_hd__decap_12
XFILLER_0_205_1291 VPWR VGND VPWR VGND sky130_ef_sc_hd__decap_12
XFILLER_0_226_424 VGND VGND VPWR VPWR sky130_fd_sc_hd__fill_2
XFILLER_0_226_402 VPWR VGND VPWR VGND sky130_ef_sc_hd__decap_12
XFILLER_0_22_1239 VPWR VGND VPWR VGND sky130_ef_sc_hd__decap_12
XFILLER_0_226_446 VGND VGND VPWR VPWR sky130_fd_sc_hd__fill_2
XFILLER_0_96_1307 VPWR VGND VPWR VGND sky130_ef_sc_hd__decap_12
XFILLER_0_226_468 VGND VGND VPWR VPWR sky130_fd_sc_hd__decap_8
XFILLER_0_210_825 VPWR VGND VPWR VGND sky130_ef_sc_hd__decap_12
XFILLER_0_132_1227 VPWR VGND VPWR VGND sky130_ef_sc_hd__decap_12
XTAP_1219 VGND VPWR sky130_fd_sc_hd__tapvpwrvgnd_1
XFILLER_0_210_869 VGND VGND VPWR VPWR sky130_fd_sc_hd__decap_8
XFILLER_0_33_1335 VGND VGND VPWR VPWR sky130_fd_sc_hd__decap_8
XFILLER_0_212_1273 VPWR VGND VPWR VGND sky130_ef_sc_hd__decap_12
XFILLER_0_18_643 VPWR VGND VPWR VGND sky130_ef_sc_hd__decap_12
XFILLER_0_107_317 VPWR VGND VPWR VGND sky130_ef_sc_hd__decap_12
XFILLER_0_143_1323 VPWR VGND VPWR VGND sky130_ef_sc_hd__decap_12
XFILLER_0_104_1329 VPWR VGND VPWR VGND sky130_ef_sc_hd__decap_12
XFILLER_0_218_925 VPWR VGND VPWR VGND sky130_ef_sc_hd__decap_12
XFILLER_0_40_1339 VGND VGND VPWR VPWR sky130_fd_sc_hd__decap_4
XANTENNA_input140_A w10[1] VGND VGND VPWR VPWR sky130_fd_sc_hd__diode_2
XFILLER_0_38_1213 VPWR VGND VPWR VGND sky130_ef_sc_hd__decap_12
XFILLER_0_213_641 VPWR VGND VPWR VGND sky130_ef_sc_hd__decap_12
XTAP_2410 VGND VPWR sky130_fd_sc_hd__tapvpwrvgnd_1
XTAP_2443 VGND VPWR sky130_fd_sc_hd__tapvpwrvgnd_1
XTAP_2432 VGND VPWR sky130_fd_sc_hd__tapvpwrvgnd_1
XTAP_2421 VGND VPWR sky130_fd_sc_hd__tapvpwrvgnd_1
XFILLER_0_213_685 VPWR VGND VPWR VGND sky130_ef_sc_hd__decap_12
XTAP_2454 VGND VPWR sky130_fd_sc_hd__tapvpwrvgnd_1
XTAP_2487 VGND VPWR sky130_fd_sc_hd__tapvpwrvgnd_1
XTAP_2476 VGND VPWR sky130_fd_sc_hd__tapvpwrvgnd_1
XFILLER_0_212_195 VGND VGND VPWR VPWR sky130_fd_sc_hd__fill_1
XTAP_2465 VGND VPWR sky130_fd_sc_hd__tapvpwrvgnd_1
XTAP_1742 VGND VPWR sky130_fd_sc_hd__tapvpwrvgnd_1
XTAP_1720 VGND VPWR sky130_fd_sc_hd__tapvpwrvgnd_1
XTAP_1731 VGND VPWR sky130_fd_sc_hd__tapvpwrvgnd_1
XTAP_2498 VGND VPWR sky130_fd_sc_hd__tapvpwrvgnd_1
XTAP_1775 VGND VPWR sky130_fd_sc_hd__tapvpwrvgnd_1
XTAP_1753 VGND VPWR sky130_fd_sc_hd__tapvpwrvgnd_1
XTAP_1764 VGND VPWR sky130_fd_sc_hd__tapvpwrvgnd_1
XFILLER_0_148_1201 VPWR VGND VPWR VGND sky130_ef_sc_hd__decap_12
XTAP_1786 VGND VPWR sky130_fd_sc_hd__tapvpwrvgnd_1
XANTENNA_u_pe10_valid_in net100 VGND VGND VPWR VPWR sky130_fd_sc_hd__diode_2
XFILLER_0_3_1233 VPWR VGND VPWR VGND sky130_ef_sc_hd__decap_12
XTAP_1797 VGND VPWR sky130_fd_sc_hd__tapvpwrvgnd_1
XFILLER_0_102_15 VPWR VGND VPWR VGND sky130_ef_sc_hd__decap_12
XFILLER_0_141_629 VPWR VGND VPWR VGND sky130_ef_sc_hd__decap_12
XFILLER_0_107_895 VGND VGND VPWR VPWR sky130_fd_sc_hd__fill_1
XFILLER_0_3_529 VPWR VGND VPWR VGND sky130_ef_sc_hd__decap_12
XFILLER_0_194_29 VPWR VGND VPWR VGND sky130_ef_sc_hd__decap_12
XFILLER_0_224_917 VGND VGND VPWR VPWR sky130_fd_sc_hd__decap_6
XFILLER_0_223_405 VPWR VGND VPWR VGND sky130_ef_sc_hd__decap_12
XFILLER_0_223_449 VPWR VGND VPWR VGND sky130_ef_sc_hd__decap_12
Xinput6 act_row0_in[14] VGND VGND VPWR VPWR net6 sky130_fd_sc_hd__clkbuf_4
XFILLER_0_155_1249 VGND VGND VPWR VPWR sky130_fd_sc_hd__decap_4
XFILLER_0_160_3 VPWR VGND VPWR VGND sky130_ef_sc_hd__decap_12
XFILLER_0_91_1237 VPWR VGND VPWR VGND sky130_ef_sc_hd__decap_12
XFILLER_0_143_22 VPWR VGND VPWR VGND sky130_ef_sc_hd__decap_12
XFILLER_0_6_301 VGND VGND VPWR VPWR sky130_fd_sc_hd__decap_6
XFILLER_0_7_813 VPWR VGND VPWR VGND sky130_ef_sc_hd__decap_12
XFILLER_0_6_345 VPWR VGND VPWR VGND sky130_ef_sc_hd__decap_12
XFILLER_0_104_309 VPWR VGND VPWR VGND sky130_ef_sc_hd__decap_12
XFILLER_0_113_821 VPWR VGND VPWR VGND sky130_ef_sc_hd__decap_12
XFILLER_0_6_389 VPWR VGND VPWR VGND sky130_ef_sc_hd__decap_12
XFILLER_0_30_605 VPWR VGND VPWR VGND sky130_ef_sc_hd__decap_12
XANTENNA_u_pe01_weight_in[12] net120 VGND VGND VPWR VPWR sky130_fd_sc_hd__diode_2
XFILLER_0_113_865 VPWR VGND VPWR VGND sky130_ef_sc_hd__decap_12
XFILLER_0_65_3 VPWR VGND VPWR VGND sky130_ef_sc_hd__decap_12
XFILLER_0_168_41 VGND VGND VPWR VPWR sky130_fd_sc_hd__decap_8
XFILLER_0_226_232 VGND VGND VPWR VPWR sky130_fd_sc_hd__decap_8
XFILLER_0_199_629 VPWR VGND VPWR VGND sky130_ef_sc_hd__decap_12
XFILLER_0_97_605 VPWR VGND VPWR VGND sky130_ef_sc_hd__decap_12
XPHY_814 VGND VGND VPWR VPWR sky130_fd_sc_hd__decap_3
XPHY_803 VGND VGND VPWR VPWR sky130_fd_sc_hd__decap_3
XPHY_836 VGND VGND VPWR VPWR sky130_fd_sc_hd__decap_3
XPHY_825 VGND VGND VPWR VPWR sky130_fd_sc_hd__decap_3
XFILLER_0_203_25 VPWR VGND VPWR VGND sky130_ef_sc_hd__decap_12
XPHY_858 VGND VGND VPWR VPWR sky130_fd_sc_hd__decap_3
XPHY_847 VGND VGND VPWR VPWR sky130_fd_sc_hd__decap_3
XPHY_869 VGND VGND VPWR VPWR sky130_fd_sc_hd__decap_3
XFILLER_0_108_637 VGND VGND VPWR VPWR sky130_fd_sc_hd__decap_6
XFILLER_0_107_125 VPWR VGND VPWR VGND sky130_ef_sc_hd__decap_12
XFILLER_0_68_1239 VPWR VGND VPWR VGND sky130_ef_sc_hd__decap_12
XFILLER_0_107_169 VPWR VGND VPWR VGND sky130_ef_sc_hd__decap_12
XFILLER_0_123_629 VPWR VGND VPWR VGND sky130_ef_sc_hd__decap_12
XFILLER_0_21_605 VPWR VGND VPWR VGND sky130_ef_sc_hd__decap_12
XFILLER_0_104_865 VGND VGND VPWR VPWR sky130_fd_sc_hd__decap_3
XFILLER_0_108_1273 VPWR VGND VPWR VGND sky130_ef_sc_hd__decap_12
XFILLER_0_178_1227 VPWR VGND VPWR VGND sky130_ef_sc_hd__decap_12
XFILLER_0_218_755 VGND VGND VPWR VPWR sky130_fd_sc_hd__fill_1
XANTENNA_input49_A psum_col0_in[23] VGND VGND VPWR VPWR sky130_fd_sc_hd__diode_2
XFILLER_0_44_1283 VPWR VGND VPWR VGND sky130_ef_sc_hd__decap_12
XFILLER_0_219_1213 VPWR VGND VPWR VGND sky130_ef_sc_hd__decap_12
XFILLER_0_79_1335 VGND VGND VPWR VPWR sky130_fd_sc_hd__decap_8
XFILLER_0_219_1257 VPWR VGND VPWR VGND sky130_ef_sc_hd__decap_12
XFILLER_0_221_909 VPWR VGND VPWR VGND sky130_ef_sc_hd__decap_12
XFILLER_0_214_961 VPWR VGND VPWR VGND sky130_ef_sc_hd__decap_12
XFILLER_0_88_605 VPWR VGND VPWR VGND sky130_ef_sc_hd__decap_12
XFILLER_0_220_419 VGND VGND VPWR VPWR sky130_fd_sc_hd__fill_1
XTAP_2251 VGND VPWR sky130_fd_sc_hd__tapvpwrvgnd_1
XTAP_2240 VGND VPWR sky130_fd_sc_hd__tapvpwrvgnd_1
XTAP_2262 VGND VPWR sky130_fd_sc_hd__tapvpwrvgnd_1
XFILLER_0_189_1323 VPWR VGND VPWR VGND sky130_ef_sc_hd__decap_12
XTAP_2295 VGND VPWR sky130_fd_sc_hd__tapvpwrvgnd_1
XTAP_2284 VGND VPWR sky130_fd_sc_hd__tapvpwrvgnd_1
XFILLER_0_115_1255 VPWR VGND VPWR VGND sky130_ef_sc_hd__decap_12
XFILLER_0_90_1281 VGND VGND VPWR VPWR sky130_fd_sc_hd__fill_1
XTAP_1550 VGND VPWR sky130_fd_sc_hd__tapvpwrvgnd_1
XTAP_2273 VGND VPWR sky130_fd_sc_hd__tapvpwrvgnd_1
XFILLER_0_111_1119 VGND VGND VPWR VPWR sky130_fd_sc_hd__fill_1
XFILLER_0_7_109 VGND VGND VPWR VPWR sky130_fd_sc_hd__decap_3
XPHY_90 VGND VGND VPWR VPWR sky130_fd_sc_hd__decap_3
XTAP_1594 VGND VPWR sky130_fd_sc_hd__tapvpwrvgnd_1
XFILLER_0_12_1227 VPWR VGND VPWR VGND sky130_ef_sc_hd__decap_12
XTAP_1561 VGND VPWR sky130_fd_sc_hd__tapvpwrvgnd_1
XTAP_1572 VGND VPWR sky130_fd_sc_hd__tapvpwrvgnd_1
XTAP_1583 VGND VPWR sky130_fd_sc_hd__tapvpwrvgnd_1
XFILLER_0_3_1063 VGND VGND VPWR VPWR sky130_fd_sc_hd__fill_1
XFILLER_0_113_69 VPWR VGND VPWR VGND sky130_ef_sc_hd__decap_12
XFILLER_0_4_805 VGND VGND VPWR VPWR sky130_fd_sc_hd__decap_6
XFILLER_0_86_1339 VGND VGND VPWR VPWR sky130_fd_sc_hd__decap_4
XFILLER_0_114_629 VPWR VGND VPWR VGND sky130_ef_sc_hd__decap_12
XFILLER_0_4_849 VPWR VGND VPWR VGND sky130_ef_sc_hd__decap_12
XFILLER_0_98_49 VGND VGND VPWR VPWR sky130_fd_sc_hd__fill_1
XFILLER_0_3_337 VPWR VGND VPWR VGND sky130_ef_sc_hd__decap_12
XFILLER_0_12_605 VPWR VGND VPWR VGND sky130_ef_sc_hd__decap_12
XFILLER_0_161_1253 VGND VGND VPWR VPWR sky130_fd_sc_hd__fill_1
XFILLER_0_110_813 VPWR VGND VPWR VGND sky130_ef_sc_hd__decap_12
XFILLER_0_23_1323 VPWR VGND VPWR VGND sky130_ef_sc_hd__decap_12
XFILLER_0_202_1283 VPWR VGND VPWR VGND sky130_ef_sc_hd__decap_12
XFILLER_0_224_725 VPWR VGND VPWR VGND sky130_ef_sc_hd__decap_12
XFILLER_0_224_769 VPWR VGND VPWR VGND sky130_ef_sc_hd__decap_12
XFILLER_0_79_605 VPWR VGND VPWR VGND sky130_ef_sc_hd__decap_12
XFILLER_0_154_10 VPWR VGND VPWR VGND sky130_ef_sc_hd__decap_12
XFILLER_0_223_279 VGND VGND VPWR VPWR sky130_fd_sc_hd__fill_1
XFILLER_0_133_1311 VPWR VGND VPWR VGND sky130_ef_sc_hd__decap_12
XFILLER_0_94_619 VPWR VGND VPWR VGND sky130_ef_sc_hd__decap_12
XFILLER_0_2_77 VGND VGND VPWR VPWR sky130_fd_sc_hd__decap_6
XFILLER_0_6_153 VPWR VGND VPWR VGND sky130_ef_sc_hd__decap_12
XFILLER_0_105_629 VPWR VGND VPWR VGND sky130_ef_sc_hd__decap_12
XFILLER_0_28_1201 VPWR VGND VPWR VGND sky130_ef_sc_hd__decap_12
XFILLER_0_6_197 VPWR VGND VPWR VGND sky130_ef_sc_hd__decap_12
XFILLER_0_113_673 VPWR VGND VPWR VGND sky130_ef_sc_hd__decap_12
XFILLER_0_70_593 VPWR VGND VPWR VGND sky130_ef_sc_hd__decap_12
XFILLER_0_140_1337 VGND VGND VPWR VPWR sky130_fd_sc_hd__fill_1
Xoutput184 net184 VGND VGND VPWR VPWR psum_col0_out[27] sky130_fd_sc_hd__clkbuf_4
Xoutput195 net195 VGND VGND VPWR VPWR psum_col0_out[8] sky130_fd_sc_hd__clkbuf_4
Xoutput173 net173 VGND VGND VPWR VPWR psum_col0_out[17] sky130_fd_sc_hd__clkbuf_4
XFILLER_0_211_953 VPWR VGND VPWR VGND sky130_ef_sc_hd__decap_12
XPHY_611 VGND VGND VPWR VPWR sky130_fd_sc_hd__decap_3
XANTENNA_u_pe11_weight_in[0] net149 VGND VGND VPWR VPWR sky130_fd_sc_hd__diode_2
XFILLER_0_35_1249 VGND VGND VPWR VPWR sky130_fd_sc_hd__decap_4
XPHY_600 VGND VGND VPWR VPWR sky130_fd_sc_hd__decap_3
XANTENNA_input103_A w00[11] VGND VGND VPWR VPWR sky130_fd_sc_hd__diode_2
XFILLER_0_210_496 VGND VGND VPWR VPWR sky130_fd_sc_hd__decap_8
XPHY_622 VGND VGND VPWR VPWR sky130_fd_sc_hd__decap_3
XFILLER_0_93_641 VGND VGND VPWR VPWR sky130_fd_sc_hd__decap_4
XFILLER_0_108_401 VPWR VGND VPWR VGND sky130_ef_sc_hd__decap_12
XPHY_633 VGND VGND VPWR VPWR sky130_fd_sc_hd__decap_3
XPHY_644 VGND VGND VPWR VPWR sky130_fd_sc_hd__decap_3
XPHY_1210 VGND VGND VPWR VPWR sky130_fd_sc_hd__decap_3
XPHY_666 VGND VGND VPWR VPWR sky130_fd_sc_hd__decap_3
XPHY_655 VGND VGND VPWR VPWR sky130_fd_sc_hd__decap_3
XFILLER_0_110_1141 VGND VGND VPWR VPWR sky130_fd_sc_hd__decap_6
XPHY_677 VGND VGND VPWR VPWR sky130_fd_sc_hd__decap_3
XFILLER_0_0_1203 VGND VGND VPWR VPWR sky130_fd_sc_hd__fill_1
XPHY_688 VGND VGND VPWR VPWR sky130_fd_sc_hd__decap_3
XFILLER_0_108_445 VPWR VGND VPWR VGND sky130_ef_sc_hd__decap_12
XPHY_699 VGND VGND VPWR VPWR sky130_fd_sc_hd__decap_3
XFILLER_0_110_1185 VPWR VGND VPWR VGND sky130_ef_sc_hd__decap_12
XFILLER_0_108_489 VPWR VGND VPWR VGND sky130_ef_sc_hd__decap_12
XFILLER_0_184_1275 VGND VGND VPWR VPWR sky130_fd_sc_hd__decap_6
XFILLER_0_145_1237 VPWR VGND VPWR VGND sky130_ef_sc_hd__decap_12
XFILLER_0_104_673 VPWR VGND VPWR VGND sky130_ef_sc_hd__decap_12
XFILLER_0_0_307 VGND VGND VPWR VPWR sky130_fd_sc_hd__fill_1
XFILLER_0_61_593 VPWR VGND VPWR VGND sky130_ef_sc_hd__decap_12
XFILLER_0_81_1225 VPWR VGND VPWR VGND sky130_ef_sc_hd__decap_12
XFILLER_0_110_109 VPWR VGND VPWR VGND sky130_ef_sc_hd__decap_12
XFILLER_0_0_329 VGND VGND VPWR VPWR sky130_fd_sc_hd__decap_6
XFILLER_0_221_1169 VGND VGND VPWR VPWR sky130_fd_sc_hd__decap_6
XFILLER_0_84_29 VPWR VGND VPWR VGND sky130_ef_sc_hd__decap_12
XFILLER_0_219_1021 VPWR VGND VPWR VGND sky130_ef_sc_hd__decap_12
XFILLER_0_191_1213 VPWR VGND VPWR VGND sky130_ef_sc_hd__decap_12
XFILLER_0_219_1065 VPWR VGND VPWR VGND sky130_ef_sc_hd__decap_12
XFILLER_0_92_1343 VGND VGND VPWR VPWR sky130_fd_sc_hd__fill_1
XFILLER_0_191_1279 VPWR VGND VPWR VGND sky130_ef_sc_hd__decap_12
XFILLER_0_186_643 VPWR VGND VPWR VGND sky130_ef_sc_hd__decap_12
XTAP_2070 VGND VPWR sky130_fd_sc_hd__tapvpwrvgnd_1
XFILLER_0_76_619 VPWR VGND VPWR VGND sky130_ef_sc_hd__decap_12
XTAP_2092 VGND VPWR sky130_fd_sc_hd__tapvpwrvgnd_1
XTAP_2081 VGND VPWR sky130_fd_sc_hd__tapvpwrvgnd_1
XTAP_1391 VGND VPWR sky130_fd_sc_hd__tapvpwrvgnd_1
XFILLER_0_5_1169 VGND VGND VPWR VPWR sky130_fd_sc_hd__decap_6
XTAP_1380 VGND VPWR sky130_fd_sc_hd__tapvpwrvgnd_1
XFILLER_0_123_3 VPWR VGND VPWR VGND sky130_ef_sc_hd__decap_12
XFILLER_0_4_613 VPWR VGND VPWR VGND sky130_ef_sc_hd__decap_12
Xinput31 act_row1_in[8] VGND VGND VPWR VPWR net31 sky130_fd_sc_hd__buf_1
Xinput20 act_row1_in[12] VGND VGND VPWR VPWR net20 sky130_fd_sc_hd__buf_1
Xinput53 psum_col0_in[27] VGND VGND VPWR VPWR net53 sky130_fd_sc_hd__buf_1
Xinput42 psum_col0_in[17] VGND VGND VPWR VPWR net42 sky130_fd_sc_hd__buf_1
Xinput64 psum_col0_in[8] VGND VGND VPWR VPWR net64 sky130_fd_sc_hd__buf_1
XFILLER_0_4_657 VPWR VGND VPWR VGND sky130_ef_sc_hd__decap_12
Xinput86 psum_col1_in[28] VGND VGND VPWR VPWR net86 sky130_fd_sc_hd__clkbuf_2
Xinput75 psum_col1_in[18] VGND VGND VPWR VPWR net75 sky130_fd_sc_hd__buf_1
Xinput97 psum_col1_in[9] VGND VGND VPWR VPWR net97 sky130_fd_sc_hd__buf_1
XFILLER_0_3_167 VGND VGND VPWR VPWR sky130_fd_sc_hd__fill_1
XFILLER_0_52_593 VPWR VGND VPWR VGND sky130_ef_sc_hd__decap_12
XFILLER_0_110_643 VGND VGND VPWR VPWR sky130_fd_sc_hd__fill_1
XFILLER_0_58_41 VGND VGND VPWR VPWR sky130_fd_sc_hd__decap_8
XFILLER_0_100_1343 VGND VGND VPWR VPWR sky130_fd_sc_hd__fill_1
XFILLER_0_224_533 VPWR VGND VPWR VGND sky130_ef_sc_hd__decap_12
XFILLER_0_58_1227 VPWR VGND VPWR VGND sky130_ef_sc_hd__decap_12
XFILLER_0_211_205 VPWR VGND VPWR VGND sky130_ef_sc_hd__decap_12
XFILLER_0_211_249 VPWR VGND VPWR VGND sky130_ef_sc_hd__decap_12
XFILLER_0_170_1319 VPWR VGND VPWR VGND sky130_ef_sc_hd__decap_12
XFILLER_0_75_641 VGND VGND VPWR VPWR sky130_fd_sc_hd__decap_4
XFILLER_0_106_905 VPWR VGND VPWR VGND sky130_ef_sc_hd__decap_12
XFILLER_0_69_1323 VPWR VGND VPWR VGND sky130_ef_sc_hd__decap_12
XFILLER_0_209_1201 VPWR VGND VPWR VGND sky130_ef_sc_hd__decap_12
XFILLER_0_106_949 VPWR VGND VPWR VGND sky130_ef_sc_hd__decap_12
XFILLER_0_90_655 VGND VGND VPWR VPWR sky130_fd_sc_hd__decap_4
XFILLER_0_7_473 VGND VGND VPWR VPWR sky130_fd_sc_hd__decap_3
XFILLER_0_209_1267 VPWR VGND VPWR VGND sky130_ef_sc_hd__decap_12
XFILLER_0_200_15 VPWR VGND VPWR VGND sky130_ef_sc_hd__decap_12
XFILLER_0_43_593 VPWR VGND VPWR VGND sky130_ef_sc_hd__decap_12
XFILLER_0_219_305 VPWR VGND VPWR VGND sky130_ef_sc_hd__decap_12
XFILLER_0_144_1281 VGND VGND VPWR VPWR sky130_fd_sc_hd__fill_1
XFILLER_0_114_993 VPWR VGND VPWR VGND sky130_ef_sc_hd__decap_12
XFILLER_0_179_1311 VPWR VGND VPWR VGND sky130_ef_sc_hd__decap_12
XFILLER_0_219_349 VPWR VGND VPWR VGND sky130_ef_sc_hd__decap_12
XFILLER_0_105_1287 VGND VGND VPWR VPWR sky130_fd_sc_hd__fill_1
XFILLER_0_41_1253 VGND VGND VPWR VPWR sky130_fd_sc_hd__fill_1
XFILLER_0_216_1205 VPWR VGND VPWR VGND sky130_ef_sc_hd__decap_12
XFILLER_0_225_34 VPWR VGND VPWR VGND sky130_ef_sc_hd__decap_12
XFILLER_0_168_643 VPWR VGND VPWR VGND sky130_ef_sc_hd__decap_12
XFILLER_0_58_619 VPWR VGND VPWR VGND sky130_ef_sc_hd__decap_12
XFILLER_0_211_783 VGND VGND VPWR VPWR sky130_fd_sc_hd__fill_1
XFILLER_0_112_1203 VGND VGND VPWR VPWR sky130_fd_sc_hd__fill_1
XFILLER_0_210_293 VPWR VGND VPWR VGND sky130_ef_sc_hd__decap_12
XFILLER_0_109_721 VGND VGND VPWR VPWR sky130_fd_sc_hd__decap_6
XPHY_430 VGND VGND VPWR VPWR sky130_fd_sc_hd__decap_3
XFILLER_0_2_1309 VGND VGND VPWR VPWR sky130_fd_sc_hd__decap_6
XFILLER_0_13_1311 VPWR VGND VPWR VGND sky130_ef_sc_hd__decap_12
XPHY_441 VGND VGND VPWR VPWR sky130_fd_sc_hd__decap_3
XPHY_452 VGND VGND VPWR VPWR sky130_fd_sc_hd__decap_3
XFILLER_0_186_1337 VGND VGND VPWR VPWR sky130_fd_sc_hd__fill_1
XPHY_1040 VGND VGND VPWR VPWR sky130_fd_sc_hd__decap_3
XFILLER_0_109_765 VPWR VGND VPWR VGND sky130_ef_sc_hd__decap_12
XPHY_485 VGND VGND VPWR VPWR sky130_fd_sc_hd__decap_3
XPHY_463 VGND VGND VPWR VPWR sky130_fd_sc_hd__decap_3
XPHY_474 VGND VGND VPWR VPWR sky130_fd_sc_hd__decap_3
XPHY_1062 VGND VGND VPWR VPWR sky130_fd_sc_hd__decap_3
XPHY_1051 VGND VGND VPWR VPWR sky130_fd_sc_hd__decap_3
XPHY_1073 VGND VGND VPWR VPWR sky130_fd_sc_hd__decap_3
XFILLER_0_0_1033 VGND VGND VPWR VPWR sky130_fd_sc_hd__decap_3
XPHY_496 VGND VGND VPWR VPWR sky130_fd_sc_hd__decap_3
XFILLER_0_108_253 VPWR VGND VPWR VGND sky130_ef_sc_hd__decap_12
XPHY_1084 VGND VGND VPWR VPWR sky130_fd_sc_hd__decap_3
XPHY_1095 VGND VGND VPWR VPWR sky130_fd_sc_hd__decap_3
XFILLER_0_0_1055 VGND VGND VPWR VPWR sky130_fd_sc_hd__decap_8
XFILLER_0_83_1309 VGND VGND VPWR VPWR sky130_fd_sc_hd__fill_1
XFILLER_0_110_15 VPWR VGND VPWR VGND sky130_ef_sc_hd__decap_12
XFILLER_0_34_593 VPWR VGND VPWR VGND sky130_ef_sc_hd__decap_12
XFILLER_0_106_1029 VGND VGND VPWR VPWR sky130_fd_sc_hd__decap_6
XFILLER_0_111_429 VPWR VGND VPWR VGND sky130_ef_sc_hd__decap_12
XFILLER_0_123_1343 VGND VGND VPWR VPWR sky130_fd_sc_hd__fill_1
XFILLER_0_95_39 VGND VGND VPWR VPWR sky130_fd_sc_hd__decap_8
XFILLER_0_20_1337 VGND VGND VPWR VPWR sky130_fd_sc_hd__fill_1
XFILLER_0_119_46 VGND VGND VPWR VPWR sky130_fd_sc_hd__decap_4
XANTENNA_u_pe00_psum_in[2] net56 VGND VGND VPWR VPWR sky130_fd_sc_hd__diode_2
XFILLER_0_221_503 VGND VGND VPWR VPWR sky130_fd_sc_hd__fill_1
XFILLER_0_14_9 VGND VGND VPWR VPWR sky130_fd_sc_hd__fill_2
XFILLER_0_57_641 VGND VGND VPWR VPWR sky130_fd_sc_hd__decap_4
XFILLER_0_5_933 VPWR VGND VPWR VGND sky130_ef_sc_hd__decap_12
XFILLER_0_72_655 VGND VGND VPWR VPWR sky130_fd_sc_hd__decap_4
XFILLER_0_4_421 VPWR VGND VPWR VGND sky130_ef_sc_hd__decap_12
XFILLER_0_5_977 VPWR VGND VPWR VGND sky130_ef_sc_hd__decap_12
XFILLER_0_25_593 VPWR VGND VPWR VGND sky130_ef_sc_hd__decap_12
XFILLER_0_25_1237 VPWR VGND VPWR VGND sky130_ef_sc_hd__decap_12
XFILLER_0_64_1275 VGND VGND VPWR VPWR sky130_fd_sc_hd__decap_6
XFILLER_0_217_809 VPWR VGND VPWR VGND sky130_ef_sc_hd__decap_12
XFILLER_0_176_41 VGND VGND VPWR VPWR sky130_fd_sc_hd__decap_8
XFILLER_0_225_853 VPWR VGND VPWR VGND sky130_ef_sc_hd__decap_12
XFILLER_0_225_897 VPWR VGND VPWR VGND sky130_ef_sc_hd__decap_12
XFILLER_0_224_363 VGND VGND VPWR VPWR sky130_fd_sc_hd__fill_1
XTAP_2817 VGND VPWR sky130_fd_sc_hd__tapvpwrvgnd_1
XFILLER_0_212_525 VGND VGND VPWR VPWR sky130_fd_sc_hd__decap_6
XTAP_2828 VGND VPWR sky130_fd_sc_hd__tapvpwrvgnd_1
XTAP_2806 VGND VPWR sky130_fd_sc_hd__tapvpwrvgnd_1
XFILLER_0_174_1263 VPWR VGND VPWR VGND sky130_ef_sc_hd__decap_12
XFILLER_0_135_1225 VPWR VGND VPWR VGND sky130_ef_sc_hd__decap_12
XANTENNA_u_pe11_act_in[6] act_10_out_11_in\[6\] VGND VGND VPWR VPWR sky130_fd_sc_hd__diode_2
XTAP_2839 VGND VPWR sky130_fd_sc_hd__tapvpwrvgnd_1
XFILLER_0_212_569 VPWR VGND VPWR VGND sky130_ef_sc_hd__decap_12
XFILLER_0_71_1213 VPWR VGND VPWR VGND sky130_ef_sc_hd__decap_12
XFILLER_0_211_1113 VGND VGND VPWR VPWR sky130_fd_sc_hd__decap_6
XFILLER_0_211_1157 VPWR VGND VPWR VGND sky130_ef_sc_hd__decap_12
XFILLER_0_71_1279 VPWR VGND VPWR VGND sky130_ef_sc_hd__decap_12
XFILLER_0_180_605 VPWR VGND VPWR VGND sky130_ef_sc_hd__decap_12
XFILLER_0_106_713 VPWR VGND VPWR VGND sky130_ef_sc_hd__decap_12
XFILLER_0_63_655 VGND VGND VPWR VPWR sky130_fd_sc_hd__fill_2
XFILLER_0_181_1201 VPWR VGND VPWR VGND sky130_ef_sc_hd__decap_12
XFILLER_0_211_69 VPWR VGND VPWR VGND sky130_ef_sc_hd__decap_12
XFILLER_0_106_757 VPWR VGND VPWR VGND sky130_ef_sc_hd__decap_12
XFILLER_0_7_281 VPWR VGND VPWR VGND sky130_ef_sc_hd__decap_12
XFILLER_0_105_223 VGND VGND VPWR VPWR sky130_fd_sc_hd__fill_1
XFILLER_0_146_1343 VGND VGND VPWR VPWR sky130_fd_sc_hd__fill_1
XFILLER_0_16_593 VPWR VGND VPWR VGND sky130_ef_sc_hd__decap_12
XFILLER_0_181_1267 VPWR VGND VPWR VGND sky130_ef_sc_hd__decap_12
XFILLER_0_82_1331 VGND VGND VPWR VPWR sky130_fd_sc_hd__decap_6
XFILLER_0_222_1253 VGND VGND VPWR VPWR sky130_fd_sc_hd__decap_6
XFILLER_0_219_113 VPWR VGND VPWR VGND sky130_ef_sc_hd__decap_12
XFILLER_0_222_1297 VPWR VGND VPWR VGND sky130_ef_sc_hd__decap_12
XANTENNA_input31_A act_row1_in[8] VGND VGND VPWR VPWR sky130_fd_sc_hd__diode_2
XFILLER_0_216_1035 VGND VGND VPWR VPWR sky130_fd_sc_hd__fill_1
XFILLER_0_215_385 VGND VGND VPWR VPWR sky130_fd_sc_hd__decap_6
XFILLER_0_153_1303 VGND VGND VPWR VPWR sky130_fd_sc_hd__decap_6
XFILLER_0_14_13 VPWR VGND VPWR VGND sky130_ef_sc_hd__decap_12
XFILLER_0_39_641 VGND VGND VPWR VPWR sky130_fd_sc_hd__decap_4
XFILLER_0_6_1253 VGND VGND VPWR VPWR sky130_fd_sc_hd__decap_6
XFILLER_0_50_1319 VPWR VGND VPWR VGND sky130_ef_sc_hd__decap_12
XFILLER_0_171_605 VPWR VGND VPWR VGND sky130_ef_sc_hd__decap_12
XFILLER_0_2_1117 VPWR VGND VPWR VGND sky130_ef_sc_hd__decap_12
XFILLER_0_6_1297 VPWR VGND VPWR VGND sky130_ef_sc_hd__decap_12
XPHY_260 VGND VGND VPWR VPWR sky130_fd_sc_hd__decap_3
XFILLER_0_109_573 VPWR VGND VPWR VGND sky130_ef_sc_hd__decap_12
XPHY_293 VGND VGND VPWR VPWR sky130_fd_sc_hd__decap_3
XPHY_271 VGND VGND VPWR VPWR sky130_fd_sc_hd__decap_3
XPHY_282 VGND VGND VPWR VPWR sky130_fd_sc_hd__decap_3
XFILLER_0_54_655 VGND VGND VPWR VPWR sky130_fd_sc_hd__decap_4
XFILLER_0_87_1253 VGND VGND VPWR VPWR sky130_fd_sc_hd__fill_1
XFILLER_0_121_47 VGND VGND VPWR VPWR sky130_fd_sc_hd__decap_3
XFILLER_0_2_925 VPWR VGND VPWR VGND sky130_ef_sc_hd__decap_12
XFILLER_0_160_1307 VPWR VGND VPWR VGND sky130_ef_sc_hd__decap_12
XFILLER_0_112_749 VGND VGND VPWR VPWR sky130_fd_sc_hd__decap_6
XFILLER_0_111_237 VPWR VGND VPWR VGND sky130_ef_sc_hd__decap_12
XFILLER_0_226_617 VGND VGND VPWR VPWR sky130_fd_sc_hd__fill_2
XFILLER_0_225_105 VGND VGND VPWR VPWR sky130_fd_sc_hd__decap_6
XFILLER_0_190_3 VPWR VGND VPWR VGND sky130_ef_sc_hd__decap_12
XFILLER_0_24_1281 VGND VGND VPWR VPWR sky130_fd_sc_hd__fill_1
XFILLER_0_225_149 VPWR VGND VPWR VGND sky130_ef_sc_hd__decap_12
XFILLER_0_158_1225 VGND VGND VPWR VPWR sky130_fd_sc_hd__fill_1
XFILLER_0_59_1311 VPWR VGND VPWR VGND sky130_ef_sc_hd__decap_12
XFILLER_0_94_1213 VPWR VGND VPWR VGND sky130_ef_sc_hd__decap_12
XFILLER_0_222_867 VGND VGND VPWR VPWR sky130_fd_sc_hd__fill_1
XFILLER_0_169_1343 VGND VGND VPWR VPWR sky130_fd_sc_hd__fill_1
XFILLER_0_162_605 VPWR VGND VPWR VGND sky130_ef_sc_hd__decap_12
XFILLER_0_45_655 VGND VGND VPWR VPWR sky130_fd_sc_hd__fill_2
XFILLER_0_5_741 VPWR VGND VPWR VGND sky130_ef_sc_hd__decap_12
XFILLER_0_95_3 VPWR VGND VPWR VGND sky130_ef_sc_hd__decap_12
XFILLER_0_4_251 VGND VGND VPWR VPWR sky130_fd_sc_hd__fill_1
XFILLER_0_66_1337 VGND VGND VPWR VPWR sky130_fd_sc_hd__fill_1
XFILLER_0_5_785 VPWR VGND VPWR VGND sky130_ef_sc_hd__decap_12
XFILLER_0_102_1213 VPWR VGND VPWR VGND sky130_ef_sc_hd__decap_12
XFILLER_0_217_617 VPWR VGND VPWR VGND sky130_ef_sc_hd__decap_12
XFILLER_0_137_1309 VGND VGND VPWR VPWR sky130_fd_sc_hd__fill_1
XTAP_2603 VGND VPWR sky130_fd_sc_hd__tapvpwrvgnd_1
XFILLER_0_206_25 VGND VGND VPWR VPWR sky130_fd_sc_hd__decap_3
XTAP_2614 VGND VPWR sky130_fd_sc_hd__tapvpwrvgnd_1
XTAP_2636 VGND VPWR sky130_fd_sc_hd__tapvpwrvgnd_1
XTAP_2625 VGND VPWR sky130_fd_sc_hd__tapvpwrvgnd_1
XFILLER_0_212_333 VPWR VGND VPWR VGND sky130_ef_sc_hd__decap_12
XTAP_2658 VGND VPWR sky130_fd_sc_hd__tapvpwrvgnd_1
XTAP_2647 VGND VPWR sky130_fd_sc_hd__tapvpwrvgnd_1
XFILLER_0_213_889 VGND VGND VPWR VPWR sky130_fd_sc_hd__decap_6
XTAP_2669 VGND VPWR sky130_fd_sc_hd__tapvpwrvgnd_1
XFILLER_0_212_377 VPWR VGND VPWR VGND sky130_ef_sc_hd__decap_12
XTAP_1902 VGND VPWR sky130_fd_sc_hd__tapvpwrvgnd_1
XTAP_1924 VGND VPWR sky130_fd_sc_hd__tapvpwrvgnd_1
XTAP_1913 VGND VPWR sky130_fd_sc_hd__tapvpwrvgnd_1
XTAP_1968 VGND VPWR sky130_fd_sc_hd__tapvpwrvgnd_1
XTAP_1946 VGND VPWR sky130_fd_sc_hd__tapvpwrvgnd_1
XTAP_1935 VGND VPWR sky130_fd_sc_hd__tapvpwrvgnd_1
XTAP_1957 VGND VPWR sky130_fd_sc_hd__tapvpwrvgnd_1
XTAP_1979 VGND VPWR sky130_fd_sc_hd__tapvpwrvgnd_1
XFILLER_0_153_605 VPWR VGND VPWR VGND sky130_ef_sc_hd__decap_12
XFILLER_0_36_655 VGND VGND VPWR VPWR sky130_fd_sc_hd__decap_4
XFILLER_0_51_647 VGND VGND VPWR VPWR sky130_fd_sc_hd__decap_8
XANTENNA_input79_A psum_col1_in[21] VGND VGND VPWR VPWR sky130_fd_sc_hd__diode_2
XFILLER_0_224_1315 VGND VGND VPWR VPWR sky130_fd_sc_hd__fill_1
XFILLER_0_107_1113 VGND VGND VPWR VPWR sky130_fd_sc_hd__decap_6
XFILLER_0_106_587 VGND VGND VPWR VPWR sky130_fd_sc_hd__fill_1
XFILLER_0_107_1157 VPWR VGND VPWR VGND sky130_ef_sc_hd__decap_12
XFILLER_0_222_1061 VPWR VGND VPWR VGND sky130_ef_sc_hd__decap_12
XFILLER_0_208_617 VGND VGND VPWR VPWR sky130_fd_sc_hd__fill_1
XANTENNA_u_pe01_load_weight net33 VGND VGND VPWR VPWR sky130_fd_sc_hd__diode_2
XANTENNA_u_pe10_weight_in[15] net139 VGND VGND VPWR VPWR sky130_fd_sc_hd__diode_2
XFILLER_0_223_609 VGND VGND VPWR VPWR sky130_fd_sc_hd__decap_6
XFILLER_0_92_29 VPWR VGND VPWR VGND sky130_ef_sc_hd__decap_12
XFILLER_0_215_193 VPWR VGND VPWR VGND sky130_ef_sc_hd__decap_12
XFILLER_0_157_1291 VPWR VGND VPWR VGND sky130_ef_sc_hd__decap_12
XFILLER_0_118_1275 VGND VGND VPWR VPWR sky130_fd_sc_hd__decap_6
XFILLER_0_114_1117 VGND VGND VPWR VPWR sky130_fd_sc_hd__decap_3
XFILLER_0_8_1337 VGND VGND VPWR VPWR sky130_fd_sc_hd__fill_1
XFILLER_0_15_1225 VPWR VGND VPWR VGND sky130_ef_sc_hd__decap_12
XFILLER_0_54_1263 VPWR VGND VPWR VGND sky130_ef_sc_hd__decap_12
XFILLER_0_6_1061 VPWR VGND VPWR VGND sky130_ef_sc_hd__decap_12
XFILLER_0_144_605 VPWR VGND VPWR VGND sky130_ef_sc_hd__decap_12
XFILLER_0_27_655 VGND VGND VPWR VPWR sky130_fd_sc_hd__fill_2
XFILLER_0_164_1251 VPWR VGND VPWR VGND sky130_ef_sc_hd__decap_12
XFILLER_0_125_1213 VPWR VGND VPWR VGND sky130_ef_sc_hd__decap_12
XFILLER_0_112_513 VPWR VGND VPWR VGND sky130_ef_sc_hd__decap_12
XFILLER_0_199_1303 VGND VGND VPWR VPWR sky130_fd_sc_hd__decap_6
XANTENNA_u_pe01_act_in[9] act_00_out_01_in\[9\] VGND VGND VPWR VPWR sky130_fd_sc_hd__diode_2
XFILLER_0_164_1295 VPWR VGND VPWR VGND sky130_ef_sc_hd__decap_12
XFILLER_0_112_557 VPWR VGND VPWR VGND sky130_ef_sc_hd__decap_12
XFILLER_0_2_755 VGND VGND VPWR VPWR sky130_fd_sc_hd__fill_1
XFILLER_0_61_1201 VPWR VGND VPWR VGND sky130_ef_sc_hd__decap_12
XFILLER_0_125_1279 VPWR VGND VPWR VGND sky130_ef_sc_hd__decap_12
XFILLER_0_26_1343 VGND VGND VPWR VPWR sky130_fd_sc_hd__fill_1
XFILLER_0_226_414 VGND VGND VPWR VPWR sky130_fd_sc_hd__decap_6
XFILLER_0_61_1267 VPWR VGND VPWR VGND sky130_ef_sc_hd__decap_12
XFILLER_0_157_10 VPWR VGND VPWR VGND sky130_ef_sc_hd__decap_12
XFILLER_0_96_1319 VPWR VGND VPWR VGND sky130_ef_sc_hd__decap_12
XFILLER_0_66_41 VGND VGND VPWR VPWR sky130_fd_sc_hd__decap_8
XFILLER_0_5_55 VGND VGND VPWR VPWR sky130_fd_sc_hd__fill_1
XFILLER_0_136_1331 VGND VGND VPWR VPWR sky130_fd_sc_hd__decap_6
XFILLER_0_210_837 VGND VGND VPWR VPWR sky130_fd_sc_hd__decap_3
XFILLER_0_171_1255 VPWR VGND VPWR VGND sky130_ef_sc_hd__decap_12
XFILLER_0_212_1241 VPWR VGND VPWR VGND sky130_ef_sc_hd__decap_12
XFILLER_0_132_1239 VPWR VGND VPWR VGND sky130_ef_sc_hd__decap_12
XFILLER_0_33_1303 VGND VGND VPWR VPWR sky130_fd_sc_hd__decap_6
XFILLER_0_212_1285 VPWR VGND VPWR VGND sky130_ef_sc_hd__decap_12
XFILLER_0_135_605 VPWR VGND VPWR VGND sky130_ef_sc_hd__decap_12
XFILLER_0_18_655 VGND VGND VPWR VPWR sky130_fd_sc_hd__decap_4
XFILLER_0_107_329 VGND VGND VPWR VPWR sky130_fd_sc_hd__decap_6
XFILLER_0_150_619 VPWR VGND VPWR VGND sky130_ef_sc_hd__decap_12
XFILLER_0_33_647 VGND VGND VPWR VPWR sky130_fd_sc_hd__decap_8
XFILLER_0_143_1335 VGND VGND VPWR VPWR sky130_fd_sc_hd__fill_1
XFILLER_0_218_937 VPWR VGND VPWR VGND sky130_ef_sc_hd__decap_12
XFILLER_0_40_1307 VPWR VGND VPWR VGND sky130_ef_sc_hd__decap_12
XFILLER_0_217_447 VGND VGND VPWR VPWR sky130_fd_sc_hd__fill_1
XFILLER_0_217_13 VPWR VGND VPWR VGND sky130_ef_sc_hd__decap_12
XFILLER_0_226_981 VGND VGND VPWR VPWR sky130_fd_sc_hd__decap_8
XFILLER_0_217_57 VPWR VGND VPWR VGND sky130_ef_sc_hd__decap_12
XANTENNA_input133_A w10[0] VGND VGND VPWR VPWR sky130_fd_sc_hd__diode_2
XTAP_2411 VGND VPWR sky130_fd_sc_hd__tapvpwrvgnd_1
XTAP_2400 VGND VPWR sky130_fd_sc_hd__tapvpwrvgnd_1
XFILLER_0_213_653 VPWR VGND VPWR VGND sky130_ef_sc_hd__decap_12
XFILLER_0_38_1225 VGND VGND VPWR VPWR sky130_fd_sc_hd__fill_1
XTAP_2444 VGND VPWR sky130_fd_sc_hd__tapvpwrvgnd_1
XFILLER_0_213_697 VPWR VGND VPWR VGND sky130_ef_sc_hd__decap_12
XTAP_2422 VGND VPWR sky130_fd_sc_hd__tapvpwrvgnd_1
XFILLER_0_212_141 VPWR VGND VPWR VGND sky130_ef_sc_hd__decap_12
XTAP_2433 VGND VPWR sky130_fd_sc_hd__tapvpwrvgnd_1
XTAP_2477 VGND VPWR sky130_fd_sc_hd__tapvpwrvgnd_1
XTAP_2455 VGND VPWR sky130_fd_sc_hd__tapvpwrvgnd_1
XTAP_2466 VGND VPWR sky130_fd_sc_hd__tapvpwrvgnd_1
XFILLER_0_150_1339 VGND VGND VPWR VPWR sky130_fd_sc_hd__decap_4
XTAP_1710 VGND VPWR sky130_fd_sc_hd__tapvpwrvgnd_1
XTAP_1721 VGND VPWR sky130_fd_sc_hd__tapvpwrvgnd_1
XTAP_1732 VGND VPWR sky130_fd_sc_hd__tapvpwrvgnd_1
XTAP_1743 VGND VPWR sky130_fd_sc_hd__tapvpwrvgnd_1
XTAP_2499 VGND VPWR sky130_fd_sc_hd__tapvpwrvgnd_1
XTAP_2488 VGND VPWR sky130_fd_sc_hd__tapvpwrvgnd_1
XTAP_1776 VGND VPWR sky130_fd_sc_hd__tapvpwrvgnd_1
XTAP_1765 VGND VPWR sky130_fd_sc_hd__tapvpwrvgnd_1
XTAP_1754 VGND VPWR sky130_fd_sc_hd__tapvpwrvgnd_1
XFILLER_0_3_1201 VPWR VGND VPWR VGND sky130_ef_sc_hd__decap_12
XTAP_1787 VGND VPWR sky130_fd_sc_hd__tapvpwrvgnd_1
XFILLER_0_126_605 VPWR VGND VPWR VGND sky130_ef_sc_hd__decap_12
XTAP_1798 VGND VPWR sky130_fd_sc_hd__tapvpwrvgnd_1
XFILLER_0_3_1245 VPWR VGND VPWR VGND sky130_ef_sc_hd__decap_12
XFILLER_0_193_593 VPWR VGND VPWR VGND sky130_ef_sc_hd__decap_12
XFILLER_0_148_1213 VPWR VGND VPWR VGND sky130_ef_sc_hd__decap_12
XFILLER_0_107_841 VPWR VGND VPWR VGND sky130_ef_sc_hd__decap_12
XFILLER_0_3_1289 VPWR VGND VPWR VGND sky130_ef_sc_hd__decap_12
XFILLER_0_102_27 VGND VGND VPWR VPWR sky130_fd_sc_hd__fill_1
XFILLER_0_11_47 VGND VGND VPWR VPWR sky130_fd_sc_hd__decap_3
XFILLER_0_49_1343 VGND VGND VPWR VPWR sky130_fd_sc_hd__fill_1
XFILLER_0_84_1201 VPWR VGND VPWR VGND sky130_ef_sc_hd__decap_12
XFILLER_0_102_49 VGND VGND VPWR VPWR sky130_fd_sc_hd__fill_1
XFILLER_0_223_417 VPWR VGND VPWR VGND sky130_ef_sc_hd__decap_12
Xinput7 act_row0_in[15] VGND VGND VPWR VPWR net7 sky130_fd_sc_hd__clkbuf_4
XFILLER_0_204_631 VPWR VGND VPWR VGND sky130_ef_sc_hd__decap_12
XFILLER_0_91_1249 VGND VGND VPWR VPWR sky130_fd_sc_hd__decap_4
XFILLER_0_17_1309 VGND VGND VPWR VPWR sky130_fd_sc_hd__fill_1
XFILLER_0_153_3 VPWR VGND VPWR VGND sky130_ef_sc_hd__decap_12
XFILLER_0_143_34 VPWR VGND VPWR VGND sky130_ef_sc_hd__decap_12
XFILLER_0_117_605 VPWR VGND VPWR VGND sky130_ef_sc_hd__decap_12
XFILLER_0_7_825 VPWR VGND VPWR VGND sky130_ef_sc_hd__decap_12
XFILLER_0_184_593 VPWR VGND VPWR VGND sky130_ef_sc_hd__decap_12
XFILLER_0_132_619 VPWR VGND VPWR VGND sky130_ef_sc_hd__decap_12
XFILLER_0_6_357 VGND VGND VPWR VPWR sky130_fd_sc_hd__decap_6
XFILLER_0_7_869 VPWR VGND VPWR VGND sky130_ef_sc_hd__decap_12
XFILLER_0_113_833 VGND VGND VPWR VPWR sky130_fd_sc_hd__decap_6
XFILLER_0_15_647 VPWR VGND VPWR VGND sky130_ef_sc_hd__decap_12
XFILLER_0_207_1343 VGND VGND VPWR VPWR sky130_fd_sc_hd__fill_1
XANTENNA_u_pe01_weight_in[11] net119 VGND VGND VPWR VPWR sky130_fd_sc_hd__diode_2
XFILLER_0_30_617 VGND VGND VPWR VPWR sky130_fd_sc_hd__fill_1
XFILLER_0_112_321 VPWR VGND VPWR VGND sky130_ef_sc_hd__decap_12
XFILLER_0_113_877 VPWR VGND VPWR VGND sky130_ef_sc_hd__decap_12
XFILLER_0_112_365 VPWR VGND VPWR VGND sky130_ef_sc_hd__decap_12
XFILLER_0_58_3 VPWR VGND VPWR VGND sky130_ef_sc_hd__decap_12
XFILLER_0_184_41 VGND VGND VPWR VPWR sky130_fd_sc_hd__decap_8
XFILLER_0_223_951 VGND VGND VPWR VPWR sky130_fd_sc_hd__fill_1
XFILLER_0_97_617 VPWR VGND VPWR VGND sky130_ef_sc_hd__decap_12
XFILLER_0_210_601 VPWR VGND VPWR VGND sky130_ef_sc_hd__decap_12
XFILLER_0_210_645 VPWR VGND VPWR VGND sky130_ef_sc_hd__decap_12
XPHY_804 VGND VGND VPWR VPWR sky130_fd_sc_hd__decap_3
XPHY_826 VGND VGND VPWR VPWR sky130_fd_sc_hd__decap_3
XPHY_815 VGND VGND VPWR VPWR sky130_fd_sc_hd__decap_3
XFILLER_0_37_1291 VPWR VGND VPWR VGND sky130_ef_sc_hd__decap_12
XFILLER_0_203_37 VPWR VGND VPWR VGND sky130_ef_sc_hd__decap_12
XPHY_859 VGND VGND VPWR VPWR sky130_fd_sc_hd__decap_3
XPHY_837 VGND VGND VPWR VPWR sky130_fd_sc_hd__decap_3
XPHY_848 VGND VGND VPWR VPWR sky130_fd_sc_hd__decap_3
XFILLER_0_212_1093 VPWR VGND VPWR VGND sky130_ef_sc_hd__decap_12
XFILLER_0_175_593 VPWR VGND VPWR VGND sky130_ef_sc_hd__decap_12
XFILLER_0_107_137 VPWR VGND VPWR VGND sky130_ef_sc_hd__decap_12
XFILLER_0_108_1241 VPWR VGND VPWR VGND sky130_ef_sc_hd__decap_12
XFILLER_0_131_641 VGND VGND VPWR VPWR sky130_fd_sc_hd__decap_4
XFILLER_0_21_617 VPWR VGND VPWR VGND sky130_ef_sc_hd__decap_12
XFILLER_0_104_1105 VPWR VGND VPWR VGND sky130_ef_sc_hd__decap_12
XFILLER_0_218_701 VPWR VGND VPWR VGND sky130_ef_sc_hd__decap_12
XFILLER_0_108_1285 VPWR VGND VPWR VGND sky130_ef_sc_hd__decap_12
XFILLER_0_104_1149 VPWR VGND VPWR VGND sky130_ef_sc_hd__decap_12
XFILLER_0_44_1251 VPWR VGND VPWR VGND sky130_ef_sc_hd__decap_12
XFILLER_0_178_1239 VPWR VGND VPWR VGND sky130_ef_sc_hd__decap_12
XFILLER_0_44_1295 VPWR VGND VPWR VGND sky130_ef_sc_hd__decap_12
XFILLER_0_79_1303 VGND VGND VPWR VPWR sky130_fd_sc_hd__decap_6
XFILLER_0_219_1225 VGND VGND VPWR VPWR sky130_fd_sc_hd__decap_6
XFILLER_0_219_1269 VPWR VGND VPWR VGND sky130_ef_sc_hd__decap_12
XFILLER_0_88_617 VGND VGND VPWR VPWR sky130_fd_sc_hd__fill_1
XFILLER_0_214_973 VGND VGND VPWR VPWR sky130_fd_sc_hd__decap_6
XFILLER_0_213_461 VPWR VGND VPWR VGND sky130_ef_sc_hd__decap_12
XFILLER_0_115_1201 VPWR VGND VPWR VGND sky130_ef_sc_hd__decap_12
XFILLER_0_201_645 VGND VGND VPWR VPWR sky130_fd_sc_hd__fill_1
XFILLER_0_154_1283 VPWR VGND VPWR VGND sky130_ef_sc_hd__decap_12
XTAP_2252 VGND VPWR sky130_fd_sc_hd__tapvpwrvgnd_1
XTAP_2230 VGND VPWR sky130_fd_sc_hd__tapvpwrvgnd_1
XTAP_2241 VGND VPWR sky130_fd_sc_hd__tapvpwrvgnd_1
XTAP_2296 VGND VPWR sky130_fd_sc_hd__tapvpwrvgnd_1
XTAP_2285 VGND VPWR sky130_fd_sc_hd__tapvpwrvgnd_1
XTAP_2263 VGND VPWR sky130_fd_sc_hd__tapvpwrvgnd_1
XFILLER_0_115_1267 VPWR VGND VPWR VGND sky130_ef_sc_hd__decap_12
XTAP_2274 VGND VPWR sky130_fd_sc_hd__tapvpwrvgnd_1
XFILLER_0_16_1331 VGND VGND VPWR VPWR sky130_fd_sc_hd__decap_6
XTAP_1540 VGND VPWR sky130_fd_sc_hd__tapvpwrvgnd_1
XTAP_1551 VGND VPWR sky130_fd_sc_hd__tapvpwrvgnd_1
XFILLER_0_189_1335 VGND VGND VPWR VPWR sky130_fd_sc_hd__decap_8
XTAP_1573 VGND VPWR sky130_fd_sc_hd__tapvpwrvgnd_1
XPHY_91 VGND VGND VPWR VPWR sky130_fd_sc_hd__decap_3
XTAP_1562 VGND VPWR sky130_fd_sc_hd__tapvpwrvgnd_1
XPHY_80 VGND VGND VPWR VPWR sky130_fd_sc_hd__decap_3
XTAP_1584 VGND VPWR sky130_fd_sc_hd__tapvpwrvgnd_1
XFILLER_0_51_1255 VPWR VGND VPWR VGND sky130_ef_sc_hd__decap_12
XFILLER_0_113_15 VPWR VGND VPWR VGND sky130_ef_sc_hd__decap_12
XFILLER_0_166_593 VPWR VGND VPWR VGND sky130_ef_sc_hd__decap_12
XFILLER_0_12_1239 VPWR VGND VPWR VGND sky130_ef_sc_hd__decap_12
XTAP_1595 VGND VPWR sky130_fd_sc_hd__tapvpwrvgnd_1
XFILLER_0_86_1307 VPWR VGND VPWR VGND sky130_ef_sc_hd__decap_12
XFILLER_0_107_671 VGND VGND VPWR VPWR sky130_fd_sc_hd__fill_1
XFILLER_0_3_305 VPWR VGND VPWR VGND sky130_ef_sc_hd__decap_12
XFILLER_0_3_349 VPWR VGND VPWR VGND sky130_ef_sc_hd__decap_12
XFILLER_0_12_617 VGND VGND VPWR VPWR sky130_fd_sc_hd__fill_1
XFILLER_0_110_825 VPWR VGND VPWR VGND sky130_ef_sc_hd__decap_12
XFILLER_0_122_1227 VPWR VGND VPWR VGND sky130_ef_sc_hd__decap_12
XFILLER_0_202_1251 VPWR VGND VPWR VGND sky130_ef_sc_hd__decap_12
XFILLER_0_110_869 VPWR VGND VPWR VGND sky130_ef_sc_hd__decap_12
XFILLER_0_23_1335 VGND VGND VPWR VPWR sky130_fd_sc_hd__fill_1
XFILLER_0_202_1295 VPWR VGND VPWR VGND sky130_ef_sc_hd__decap_12
XFILLER_0_196_1339 VGND VGND VPWR VPWR sky130_fd_sc_hd__decap_3
XFILLER_0_224_737 VPWR VGND VPWR VGND sky130_ef_sc_hd__decap_12
XFILLER_0_223_225 VPWR VGND VPWR VGND sky130_ef_sc_hd__decap_12
XFILLER_0_79_617 VPWR VGND VPWR VGND sky130_ef_sc_hd__decap_12
XFILLER_0_154_22 VGND VGND VPWR VPWR sky130_fd_sc_hd__decap_6
XFILLER_0_189_641 VGND VGND VPWR VPWR sky130_fd_sc_hd__decap_4
XFILLER_0_133_1323 VPWR VGND VPWR VGND sky130_ef_sc_hd__decap_12
XFILLER_0_157_593 VPWR VGND VPWR VGND sky130_ef_sc_hd__decap_12
XFILLER_0_30_1339 VGND VGND VPWR VPWR sky130_fd_sc_hd__decap_4
XFILLER_0_6_121 VPWR VGND VPWR VGND sky130_ef_sc_hd__decap_12
XFILLER_0_6_165 VPWR VGND VPWR VGND sky130_ef_sc_hd__decap_12
XFILLER_0_113_641 VPWR VGND VPWR VGND sky130_ef_sc_hd__decap_12
XFILLER_0_28_1213 VPWR VGND VPWR VGND sky130_ef_sc_hd__decap_12
XFILLER_0_113_685 VPWR VGND VPWR VGND sky130_ef_sc_hd__decap_12
Xoutput185 net185 VGND VGND VPWR VPWR psum_col0_out[28] sky130_fd_sc_hd__clkbuf_4
Xoutput174 net174 VGND VGND VPWR VPWR psum_col0_out[18] sky130_fd_sc_hd__clkbuf_4
XFILLER_0_112_195 VGND VGND VPWR VPWR sky130_fd_sc_hd__fill_1
Xoutput196 net196 VGND VGND VPWR VPWR psum_col0_out[9] sky130_fd_sc_hd__clkbuf_4
XFILLER_0_138_1201 VPWR VGND VPWR VGND sky130_ef_sc_hd__decap_12
XFILLER_0_211_921 VPWR VGND VPWR VGND sky130_ef_sc_hd__decap_12
XFILLER_0_211_965 VPWR VGND VPWR VGND sky130_ef_sc_hd__decap_12
XPHY_601 VGND VGND VPWR VPWR sky130_fd_sc_hd__decap_3
XPHY_634 VGND VGND VPWR VPWR sky130_fd_sc_hd__decap_3
XPHY_623 VGND VGND VPWR VPWR sky130_fd_sc_hd__decap_3
XPHY_612 VGND VGND VPWR VPWR sky130_fd_sc_hd__decap_3
XPHY_1211 VGND VGND VPWR VPWR sky130_fd_sc_hd__decap_3
XPHY_1200 VGND VGND VPWR VPWR sky130_fd_sc_hd__decap_3
XPHY_678 VGND VGND VPWR VPWR sky130_fd_sc_hd__decap_3
XPHY_667 VGND VGND VPWR VPWR sky130_fd_sc_hd__decap_3
XFILLER_0_148_593 VPWR VGND VPWR VGND sky130_ef_sc_hd__decap_12
XFILLER_0_108_413 VGND VGND VPWR VPWR sky130_fd_sc_hd__decap_6
XPHY_645 VGND VGND VPWR VPWR sky130_fd_sc_hd__decap_3
XPHY_656 VGND VGND VPWR VPWR sky130_fd_sc_hd__decap_3
XPHY_689 VGND VGND VPWR VPWR sky130_fd_sc_hd__decap_3
XFILLER_0_108_457 VPWR VGND VPWR VGND sky130_ef_sc_hd__decap_12
XFILLER_0_110_1197 VGND VGND VPWR VPWR sky130_fd_sc_hd__decap_6
XFILLER_0_145_1249 VGND VGND VPWR VPWR sky130_fd_sc_hd__decap_4
XFILLER_0_104_641 VGND VGND VPWR VPWR sky130_fd_sc_hd__decap_3
XFILLER_0_1_809 VPWR VGND VPWR VGND sky130_ef_sc_hd__decap_12
XANTENNA_input61_A psum_col0_in[5] VGND VGND VPWR VPWR sky130_fd_sc_hd__diode_2
XFILLER_0_81_1237 VPWR VGND VPWR VGND sky130_ef_sc_hd__decap_12
XFILLER_0_104_685 VPWR VGND VPWR VGND sky130_ef_sc_hd__decap_12
XFILLER_0_108_1093 VPWR VGND VPWR VGND sky130_ef_sc_hd__decap_12
XFILLER_0_218_531 VGND VGND VPWR VPWR sky130_fd_sc_hd__fill_1
XFILLER_0_17_13 VPWR VGND VPWR VGND sky130_ef_sc_hd__decap_12
XFILLER_0_219_1033 VPWR VGND VPWR VGND sky130_ef_sc_hd__decap_12
XFILLER_0_191_1225 VPWR VGND VPWR VGND sky130_ef_sc_hd__decap_12
XFILLER_0_219_1077 VPWR VGND VPWR VGND sky130_ef_sc_hd__decap_12
XFILLER_0_221_729 VPWR VGND VPWR VGND sky130_ef_sc_hd__decap_12
XFILLER_0_214_781 VPWR VGND VPWR VGND sky130_ef_sc_hd__decap_12
XFILLER_0_186_655 VGND VGND VPWR VPWR sky130_fd_sc_hd__decap_4
XTAP_2060 VGND VPWR sky130_fd_sc_hd__tapvpwrvgnd_1
XTAP_2093 VGND VPWR sky130_fd_sc_hd__tapvpwrvgnd_1
XTAP_2071 VGND VPWR sky130_fd_sc_hd__tapvpwrvgnd_1
XTAP_2082 VGND VPWR sky130_fd_sc_hd__tapvpwrvgnd_1
XFILLER_0_84_631 VPWR VGND VPWR VGND sky130_ef_sc_hd__decap_12
XFILLER_0_139_593 VPWR VGND VPWR VGND sky130_ef_sc_hd__decap_12
XTAP_1370 VGND VPWR sky130_fd_sc_hd__tapvpwrvgnd_1
XTAP_1392 VGND VPWR sky130_fd_sc_hd__tapvpwrvgnd_1
XTAP_1381 VGND VPWR sky130_fd_sc_hd__tapvpwrvgnd_1
Xinput10 act_row0_in[3] VGND VGND VPWR VPWR net10 sky130_fd_sc_hd__clkbuf_4
XFILLER_0_4_625 VPWR VGND VPWR VGND sky130_ef_sc_hd__decap_12
Xinput21 act_row1_in[13] VGND VGND VPWR VPWR net21 sky130_fd_sc_hd__buf_1
XFILLER_0_114_405 VPWR VGND VPWR VGND sky130_ef_sc_hd__decap_12
XFILLER_0_116_3 VPWR VGND VPWR VGND sky130_ef_sc_hd__decap_12
Xinput54 psum_col0_in[28] VGND VGND VPWR VPWR net54 sky130_fd_sc_hd__buf_1
Xinput43 psum_col0_in[18] VGND VGND VPWR VPWR net43 sky130_fd_sc_hd__buf_1
XFILLER_0_3_113 VPWR VGND VPWR VGND sky130_ef_sc_hd__decap_12
Xinput32 act_row1_in[9] VGND VGND VPWR VPWR net32 sky130_fd_sc_hd__buf_1
XFILLER_0_114_449 VPWR VGND VPWR VGND sky130_ef_sc_hd__decap_12
Xinput87 psum_col1_in[29] VGND VGND VPWR VPWR net87 sky130_fd_sc_hd__clkbuf_2
Xinput76 psum_col1_in[19] VGND VGND VPWR VPWR net76 sky130_fd_sc_hd__buf_1
Xinput65 psum_col0_in[9] VGND VGND VPWR VPWR net65 sky130_fd_sc_hd__buf_1
XFILLER_0_4_669 VPWR VGND VPWR VGND sky130_ef_sc_hd__decap_12
Xinput98 rst_n VGND VGND VPWR VPWR net98 sky130_fd_sc_hd__clkbuf_16
XFILLER_0_110_699 VGND VGND VPWR VPWR sky130_fd_sc_hd__fill_1
XFILLER_0_0_897 VGND VGND VPWR VPWR sky130_fd_sc_hd__decap_8
XFILLER_0_224_501 VPWR VGND VPWR VGND sky130_ef_sc_hd__decap_12
XFILLER_0_97_1255 VPWR VGND VPWR VGND sky130_ef_sc_hd__decap_12
XFILLER_0_224_545 VPWR VGND VPWR VGND sky130_ef_sc_hd__decap_12
XFILLER_0_74_41 VGND VGND VPWR VPWR sky130_fd_sc_hd__decap_8
XFILLER_0_58_1239 VPWR VGND VPWR VGND sky130_ef_sc_hd__decap_12
XFILLER_0_224_589 VPWR VGND VPWR VGND sky130_ef_sc_hd__decap_12
XFILLER_0_211_217 VGND VGND VPWR VPWR sky130_fd_sc_hd__decap_6
XFILLER_0_177_655 VGND VGND VPWR VPWR sky130_fd_sc_hd__fill_2
XFILLER_0_34_1283 VPWR VGND VPWR VGND sky130_ef_sc_hd__decap_12
XFILLER_0_168_1227 VPWR VGND VPWR VGND sky130_ef_sc_hd__decap_12
XFILLER_0_69_1335 VGND VGND VPWR VPWR sky130_fd_sc_hd__decap_8
XFILLER_0_209_1213 VPWR VGND VPWR VGND sky130_ef_sc_hd__decap_12
XFILLER_0_106_917 VGND VGND VPWR VPWR sky130_fd_sc_hd__decap_6
XFILLER_0_105_405 VPWR VGND VPWR VGND sky130_ef_sc_hd__decap_12
XFILLER_0_200_27 VGND VGND VPWR VPWR sky130_fd_sc_hd__fill_1
XFILLER_0_105_449 VPWR VGND VPWR VGND sky130_ef_sc_hd__decap_12
XFILLER_0_209_1279 VPWR VGND VPWR VGND sky130_ef_sc_hd__decap_12
XFILLER_0_200_49 VGND VGND VPWR VPWR sky130_fd_sc_hd__fill_1
XFILLER_0_219_317 VPWR VGND VPWR VGND sky130_ef_sc_hd__decap_12
XFILLER_0_105_1233 VPWR VGND VPWR VGND sky130_ef_sc_hd__decap_12
XFILLER_0_179_1323 VGND VGND VPWR VPWR sky130_fd_sc_hd__decap_8
XFILLER_0_80_1281 VGND VGND VPWR VPWR sky130_fd_sc_hd__fill_1
XFILLER_0_209_47 VGND VGND VPWR VPWR sky130_fd_sc_hd__decap_3
XFILLER_0_216_1217 VPWR VGND VPWR VGND sky130_ef_sc_hd__decap_12
XFILLER_0_76_1339 VGND VGND VPWR VPWR sky130_fd_sc_hd__decap_4
XFILLER_0_225_57 VPWR VGND VPWR VGND sky130_ef_sc_hd__decap_12
XFILLER_0_225_46 VGND VGND VPWR VPWR sky130_fd_sc_hd__decap_8
XFILLER_0_151_1253 VGND VGND VPWR VPWR sky130_fd_sc_hd__fill_1
XFILLER_0_168_655 VGND VGND VPWR VPWR sky130_fd_sc_hd__decap_4
XFILLER_0_66_631 VPWR VGND VPWR VGND sky130_ef_sc_hd__decap_12
XFILLER_0_183_647 VGND VGND VPWR VPWR sky130_fd_sc_hd__decap_8
XFILLER_0_112_1259 VGND VGND VPWR VPWR sky130_fd_sc_hd__fill_1
XPHY_442 VGND VGND VPWR VPWR sky130_fd_sc_hd__decap_3
XPHY_431 VGND VGND VPWR VPWR sky130_fd_sc_hd__decap_3
XPHY_420 VGND VGND VPWR VPWR sky130_fd_sc_hd__decap_3
XFILLER_0_13_1323 VPWR VGND VPWR VGND sky130_ef_sc_hd__decap_12
XPHY_453 VGND VGND VPWR VPWR sky130_fd_sc_hd__decap_3
XPHY_1030 VGND VGND VPWR VPWR sky130_fd_sc_hd__decap_3
XPHY_1041 VGND VGND VPWR VPWR sky130_fd_sc_hd__decap_3
XPHY_475 VGND VGND VPWR VPWR sky130_fd_sc_hd__decap_3
XPHY_486 VGND VGND VPWR VPWR sky130_fd_sc_hd__decap_3
XPHY_464 VGND VGND VPWR VPWR sky130_fd_sc_hd__decap_3
XFILLER_0_108_221 VPWR VGND VPWR VGND sky130_ef_sc_hd__decap_12
XPHY_1074 VGND VGND VPWR VPWR sky130_fd_sc_hd__decap_3
XPHY_1063 VGND VGND VPWR VPWR sky130_fd_sc_hd__decap_3
XPHY_1052 VGND VGND VPWR VPWR sky130_fd_sc_hd__decap_3
XFILLER_0_109_777 VGND VGND VPWR VPWR sky130_fd_sc_hd__decap_6
XFILLER_0_81_645 VGND VGND VPWR VPWR sky130_fd_sc_hd__fill_1
XPHY_497 VGND VGND VPWR VPWR sky130_fd_sc_hd__decap_3
XFILLER_0_108_265 VPWR VGND VPWR VGND sky130_ef_sc_hd__decap_12
XPHY_1096 VGND VGND VPWR VPWR sky130_fd_sc_hd__decap_3
XPHY_1085 VGND VGND VPWR VPWR sky130_fd_sc_hd__decap_3
XFILLER_0_1_617 VPWR VGND VPWR VGND sky130_ef_sc_hd__decap_12
XFILLER_0_110_27 VGND VGND VPWR VPWR sky130_fd_sc_hd__fill_1
XFILLER_0_123_1311 VPWR VGND VPWR VGND sky130_ef_sc_hd__decap_12
XFILLER_0_193_1309 VGND VGND VPWR VPWR sky130_fd_sc_hd__fill_1
XFILLER_0_219_895 VGND VGND VPWR VPWR sky130_fd_sc_hd__fill_1
XANTENNA_u_pe00_psum_in[1] net45 VGND VGND VPWR VPWR sky130_fd_sc_hd__diode_2
XFILLER_0_18_1201 VPWR VGND VPWR VGND sky130_ef_sc_hd__decap_12
XFILLER_0_221_559 VGND VGND VPWR VPWR sky130_fd_sc_hd__fill_1
XFILLER_0_159_655 VGND VGND VPWR VPWR sky130_fd_sc_hd__fill_2
XFILLER_0_130_1337 VGND VGND VPWR VPWR sky130_fd_sc_hd__fill_1
XFILLER_0_4_433 VPWR VGND VPWR VGND sky130_ef_sc_hd__decap_12
XFILLER_0_5_945 VGND VGND VPWR VPWR sky130_fd_sc_hd__decap_6
XFILLER_0_5_989 VPWR VGND VPWR VGND sky130_ef_sc_hd__decap_12
XFILLER_0_4_477 VPWR VGND VPWR VGND sky130_ef_sc_hd__decap_12
XFILLER_0_111_953 VPWR VGND VPWR VGND sky130_ef_sc_hd__decap_12
XFILLER_0_25_1249 VGND VGND VPWR VPWR sky130_fd_sc_hd__decap_4
XFILLER_0_225_821 VPWR VGND VPWR VGND sky130_ef_sc_hd__decap_12
XFILLER_0_216_309 VPWR VGND VPWR VGND sky130_ef_sc_hd__decap_12
XFILLER_0_40_3 VPWR VGND VPWR VGND sky130_ef_sc_hd__decap_12
XFILLER_0_225_865 VPWR VGND VPWR VGND sky130_ef_sc_hd__decap_12
XTAP_2818 VGND VPWR sky130_fd_sc_hd__tapvpwrvgnd_1
XTAP_2807 VGND VPWR sky130_fd_sc_hd__tapvpwrvgnd_1
XFILLER_0_192_41 VGND VGND VPWR VPWR sky130_fd_sc_hd__decap_8
XFILLER_0_174_1275 VGND VGND VPWR VPWR sky130_fd_sc_hd__decap_6
XANTENNA_u_pe11_act_in[5] act_10_out_11_in\[5\] VGND VGND VPWR VPWR sky130_fd_sc_hd__diode_2
XTAP_2829 VGND VPWR sky130_fd_sc_hd__tapvpwrvgnd_1
XFILLER_0_135_1237 VPWR VGND VPWR VGND sky130_ef_sc_hd__decap_12
XFILLER_0_71_1225 VPWR VGND VPWR VGND sky130_ef_sc_hd__decap_12
XFILLER_0_220_581 VGND VGND VPWR VPWR sky130_fd_sc_hd__decap_6
XFILLER_0_48_631 VPWR VGND VPWR VGND sky130_ef_sc_hd__decap_12
XFILLER_0_211_1169 VGND VGND VPWR VPWR sky130_fd_sc_hd__decap_6
XFILLER_0_165_647 VGND VGND VPWR VPWR sky130_fd_sc_hd__decap_8
XFILLER_0_180_617 VGND VGND VPWR VPWR sky130_fd_sc_hd__fill_1
XFILLER_0_211_15 VPWR VGND VPWR VGND sky130_ef_sc_hd__decap_12
XFILLER_0_111_1281 VGND VGND VPWR VPWR sky130_fd_sc_hd__decap_6
XFILLER_0_106_725 VPWR VGND VPWR VGND sky130_ef_sc_hd__decap_12
XFILLER_0_63_645 VGND VGND VPWR VPWR sky130_fd_sc_hd__fill_1
XFILLER_0_1_1332 VGND VGND VPWR VPWR sky130_fd_sc_hd__decap_4
XFILLER_0_7_293 VPWR VGND VPWR VGND sky130_ef_sc_hd__decap_12
XFILLER_0_181_1213 VPWR VGND VPWR VGND sky130_ef_sc_hd__decap_12
XFILLER_0_106_769 VPWR VGND VPWR VGND sky130_ef_sc_hd__decap_12
XFILLER_0_181_1279 VPWR VGND VPWR VGND sky130_ef_sc_hd__decap_12
XFILLER_0_82_1343 VGND VGND VPWR VPWR sky130_fd_sc_hd__fill_1
XFILLER_0_105_279 VGND VGND VPWR VPWR sky130_fd_sc_hd__fill_1
XANTENNA_input163_A w11[8] VGND VGND VPWR VPWR sky130_fd_sc_hd__diode_2
XFILLER_0_219_125 VPWR VGND VPWR VGND sky130_ef_sc_hd__decap_12
XFILLER_0_105_1063 VGND VGND VPWR VPWR sky130_fd_sc_hd__fill_1
XANTENNA_u_pe00_load_weight net33 VGND VGND VPWR VPWR sky130_fd_sc_hd__diode_2
XFILLER_0_219_169 VPWR VGND VPWR VGND sky130_ef_sc_hd__decap_12
XFILLER_0_192_1331 VGND VGND VPWR VPWR sky130_fd_sc_hd__decap_6
XANTENNA_input24_A act_row1_in[1] VGND VGND VPWR VPWR sky130_fd_sc_hd__diode_2
XFILLER_0_14_25 VGND VGND VPWR VPWR sky130_fd_sc_hd__decap_3
XFILLER_0_109_541 VPWR VGND VPWR VGND sky130_ef_sc_hd__decap_12
XPHY_250 VGND VGND VPWR VPWR sky130_fd_sc_hd__decap_3
XFILLER_0_2_1129 VPWR VGND VPWR VGND sky130_ef_sc_hd__decap_12
XPHY_261 VGND VGND VPWR VPWR sky130_fd_sc_hd__decap_3
XFILLER_0_171_617 VPWR VGND VPWR VGND sky130_ef_sc_hd__decap_12
XPHY_294 VGND VGND VPWR VPWR sky130_fd_sc_hd__decap_3
XPHY_283 VGND VGND VPWR VPWR sky130_fd_sc_hd__decap_3
XPHY_272 VGND VGND VPWR VPWR sky130_fd_sc_hd__decap_3
XFILLER_0_121_15 VPWR VGND VPWR VGND sky130_ef_sc_hd__decap_12
XFILLER_0_109_585 VPWR VGND VPWR VGND sky130_ef_sc_hd__decap_12
XFILLER_0_48_1227 VPWR VGND VPWR VGND sky130_ef_sc_hd__decap_12
XFILLER_0_223_1007 VGND VGND VPWR VPWR sky130_fd_sc_hd__fill_1
XFILLER_0_160_1319 VPWR VGND VPWR VGND sky130_ef_sc_hd__decap_12
XFILLER_0_2_937 VPWR VGND VPWR VGND sky130_ef_sc_hd__decap_12
XFILLER_0_111_205 VPWR VGND VPWR VGND sky130_ef_sc_hd__decap_12
XFILLER_0_1_447 VGND VGND VPWR VPWR sky130_fd_sc_hd__fill_1
XFILLER_0_111_249 VPWR VGND VPWR VGND sky130_ef_sc_hd__decap_12
XFILLER_0_197_1253 VGND VGND VPWR VPWR sky130_fd_sc_hd__fill_1
XFILLER_0_183_3 VPWR VGND VPWR VGND sky130_ef_sc_hd__decap_12
XFILLER_0_222_813 VPWR VGND VPWR VGND sky130_ef_sc_hd__decap_12
XFILLER_0_94_1225 VGND VGND VPWR VPWR sky130_fd_sc_hd__fill_1
XFILLER_0_59_1323 VPWR VGND VPWR VGND sky130_ef_sc_hd__decap_12
XFILLER_0_134_1281 VGND VGND VPWR VPWR sky130_fd_sc_hd__fill_1
XFILLER_0_169_1311 VPWR VGND VPWR VGND sky130_ef_sc_hd__decap_12
XFILLER_0_147_647 VGND VGND VPWR VPWR sky130_fd_sc_hd__decap_8
XFILLER_0_162_617 VGND VGND VPWR VPWR sky130_fd_sc_hd__fill_1
XFILLER_0_45_645 VGND VGND VPWR VPWR sky130_fd_sc_hd__fill_1
XFILLER_0_31_1253 VGND VGND VPWR VPWR sky130_fd_sc_hd__fill_1
XFILLER_0_5_753 VPWR VGND VPWR VGND sky130_ef_sc_hd__decap_12
XFILLER_0_88_3 VPWR VGND VPWR VGND sky130_ef_sc_hd__decap_12
XFILLER_0_206_1227 VPWR VGND VPWR VGND sky130_ef_sc_hd__decap_12
XFILLER_0_5_797 VPWR VGND VPWR VGND sky130_ef_sc_hd__decap_12
XFILLER_0_111_81 VPWR VGND VPWR VGND sky130_ef_sc_hd__decap_12
XFILLER_0_111_783 VGND VGND VPWR VPWR sky130_fd_sc_hd__fill_1
XFILLER_0_217_629 VPWR VGND VPWR VGND sky130_ef_sc_hd__decap_12
XFILLER_0_102_1225 VGND VGND VPWR VPWR sky130_fd_sc_hd__fill_1
XFILLER_0_216_139 VGND VGND VPWR VPWR sky130_fd_sc_hd__fill_1
XFILLER_0_217_1301 VPWR VGND VPWR VGND sky130_ef_sc_hd__decap_12
XFILLER_0_176_1337 VGND VGND VPWR VPWR sky130_fd_sc_hd__fill_1
XFILLER_0_225_673 VPWR VGND VPWR VGND sky130_ef_sc_hd__decap_12
XFILLER_0_212_301 VGND VGND VPWR VPWR sky130_fd_sc_hd__decap_6
XFILLER_0_73_1309 VGND VGND VPWR VPWR sky130_fd_sc_hd__fill_1
XTAP_2604 VGND VPWR sky130_fd_sc_hd__tapvpwrvgnd_1
XTAP_2626 VGND VPWR sky130_fd_sc_hd__tapvpwrvgnd_1
XTAP_2615 VGND VPWR sky130_fd_sc_hd__tapvpwrvgnd_1
XFILLER_0_212_345 VPWR VGND VPWR VGND sky130_ef_sc_hd__decap_12
XTAP_2659 VGND VPWR sky130_fd_sc_hd__tapvpwrvgnd_1
XTAP_2637 VGND VPWR sky130_fd_sc_hd__tapvpwrvgnd_1
XTAP_2648 VGND VPWR sky130_fd_sc_hd__tapvpwrvgnd_1
XFILLER_0_212_389 VPWR VGND VPWR VGND sky130_ef_sc_hd__decap_12
XTAP_1903 VGND VPWR sky130_fd_sc_hd__tapvpwrvgnd_1
XTAP_1925 VGND VPWR sky130_fd_sc_hd__tapvpwrvgnd_1
XTAP_1914 VGND VPWR sky130_fd_sc_hd__tapvpwrvgnd_1
XTAP_1947 VGND VPWR sky130_fd_sc_hd__tapvpwrvgnd_1
XTAP_1936 VGND VPWR sky130_fd_sc_hd__tapvpwrvgnd_1
XTAP_1958 VGND VPWR sky130_fd_sc_hd__tapvpwrvgnd_1
XTAP_1969 VGND VPWR sky130_fd_sc_hd__tapvpwrvgnd_1
XFILLER_0_153_617 VPWR VGND VPWR VGND sky130_ef_sc_hd__decap_12
XFILLER_0_106_533 VPWR VGND VPWR VGND sky130_ef_sc_hd__decap_12
XFILLER_0_10_1337 VGND VGND VPWR VPWR sky130_fd_sc_hd__fill_1
XFILLER_0_107_1169 VGND VGND VPWR VPWR sky130_fd_sc_hd__decap_6
XFILLER_0_222_1073 VPWR VGND VPWR VGND sky130_ef_sc_hd__decap_12
XANTENNA_u_pe10_weight_in[14] net138 VGND VGND VPWR VPWR sky130_fd_sc_hd__diode_2
XFILLER_0_222_109 VPWR VGND VPWR VGND sky130_ef_sc_hd__decap_12
XFILLER_0_215_161 VGND VGND VPWR VPWR sky130_fd_sc_hd__decap_6
XFILLER_0_116_15 VPWR VGND VPWR VGND sky130_ef_sc_hd__decap_12
XFILLER_0_93_1291 VPWR VGND VPWR VGND sky130_ef_sc_hd__decap_12
XFILLER_0_15_1237 VPWR VGND VPWR VGND sky130_ef_sc_hd__decap_12
XFILLER_0_54_1275 VGND VGND VPWR VPWR sky130_fd_sc_hd__decap_6
XFILLER_0_129_647 VGND VGND VPWR VPWR sky130_fd_sc_hd__decap_8
XFILLER_0_6_1073 VPWR VGND VPWR VGND sky130_ef_sc_hd__decap_12
XFILLER_0_144_617 VGND VGND VPWR VPWR sky130_fd_sc_hd__fill_1
XFILLER_0_27_645 VGND VGND VPWR VPWR sky130_fd_sc_hd__fill_1
XFILLER_0_109_393 VPWR VGND VPWR VGND sky130_ef_sc_hd__decap_12
XFILLER_0_164_1263 VPWR VGND VPWR VGND sky130_ef_sc_hd__decap_12
XFILLER_0_112_525 VGND VGND VPWR VPWR sky130_fd_sc_hd__decap_6
XFILLER_0_2_701 VPWR VGND VPWR VGND sky130_ef_sc_hd__decap_12
XANTENNA_u_pe01_act_in[8] act_00_out_01_in\[8\] VGND VGND VPWR VPWR sky130_fd_sc_hd__diode_2
XFILLER_0_125_1225 VPWR VGND VPWR VGND sky130_ef_sc_hd__decap_12
XFILLER_0_61_1213 VPWR VGND VPWR VGND sky130_ef_sc_hd__decap_12
XFILLER_0_112_569 VPWR VGND VPWR VGND sky130_ef_sc_hd__decap_12
XFILLER_0_61_1279 VPWR VGND VPWR VGND sky130_ef_sc_hd__decap_12
XFILLER_0_157_22 VPWR VGND VPWR VGND sky130_ef_sc_hd__decap_12
XFILLER_0_101_1291 VPWR VGND VPWR VGND sky130_ef_sc_hd__decap_12
XFILLER_0_222_643 VGND VGND VPWR VPWR sky130_fd_sc_hd__fill_1
XFILLER_0_171_1201 VPWR VGND VPWR VGND sky130_ef_sc_hd__decap_12
XFILLER_0_136_1343 VGND VGND VPWR VPWR sky130_fd_sc_hd__fill_1
XFILLER_0_82_41 VGND VGND VPWR VPWR sky130_fd_sc_hd__decap_8
XFILLER_0_171_1267 VPWR VGND VPWR VGND sky130_ef_sc_hd__decap_12
XFILLER_0_72_1331 VGND VGND VPWR VPWR sky130_fd_sc_hd__decap_6
XFILLER_0_212_1253 VGND VGND VPWR VPWR sky130_fd_sc_hd__decap_6
XFILLER_0_212_1297 VPWR VGND VPWR VGND sky130_ef_sc_hd__decap_12
XFILLER_0_135_617 VPWR VGND VPWR VGND sky130_ef_sc_hd__decap_12
XFILLER_0_143_1303 VGND VGND VPWR VPWR sky130_fd_sc_hd__decap_6
XFILLER_0_5_561 VPWR VGND VPWR VGND sky130_ef_sc_hd__decap_12
XFILLER_0_218_905 VPWR VGND VPWR VGND sky130_ef_sc_hd__decap_12
XFILLER_0_40_1319 VPWR VGND VPWR VGND sky130_ef_sc_hd__decap_12
XFILLER_0_218_949 VPWR VGND VPWR VGND sky130_ef_sc_hd__decap_12
XFILLER_0_217_25 VPWR VGND VPWR VGND sky130_ef_sc_hd__decap_12
XFILLER_0_77_1253 VGND VGND VPWR VPWR sky130_fd_sc_hd__fill_1
XFILLER_0_217_69 VPWR VGND VPWR VGND sky130_ef_sc_hd__decap_12
XTAP_2401 VGND VPWR sky130_fd_sc_hd__tapvpwrvgnd_1
XANTENNA_input126_A w01[3] VGND VGND VPWR VPWR sky130_fd_sc_hd__diode_2
XFILLER_0_217_1175 VGND VGND VPWR VPWR sky130_fd_sc_hd__fill_1
XTAP_2445 VGND VPWR sky130_fd_sc_hd__tapvpwrvgnd_1
XTAP_2423 VGND VPWR sky130_fd_sc_hd__tapvpwrvgnd_1
XTAP_2412 VGND VPWR sky130_fd_sc_hd__tapvpwrvgnd_1
XFILLER_0_213_665 VGND VGND VPWR VPWR sky130_fd_sc_hd__decap_6
XTAP_2434 VGND VPWR sky130_fd_sc_hd__tapvpwrvgnd_1
XFILLER_0_212_153 VPWR VGND VPWR VGND sky130_ef_sc_hd__decap_12
XFILLER_0_150_1307 VPWR VGND VPWR VGND sky130_ef_sc_hd__decap_12
XTAP_1700 VGND VPWR sky130_fd_sc_hd__tapvpwrvgnd_1
XTAP_2467 VGND VPWR sky130_fd_sc_hd__tapvpwrvgnd_1
XTAP_2456 VGND VPWR sky130_fd_sc_hd__tapvpwrvgnd_1
XTAP_2478 VGND VPWR sky130_fd_sc_hd__tapvpwrvgnd_1
XFILLER_0_212_197 VPWR VGND VPWR VGND sky130_ef_sc_hd__decap_12
XTAP_1733 VGND VPWR sky130_fd_sc_hd__tapvpwrvgnd_1
XTAP_1722 VGND VPWR sky130_fd_sc_hd__tapvpwrvgnd_1
XTAP_1711 VGND VPWR sky130_fd_sc_hd__tapvpwrvgnd_1
XTAP_2489 VGND VPWR sky130_fd_sc_hd__tapvpwrvgnd_1
XTAP_1766 VGND VPWR sky130_fd_sc_hd__tapvpwrvgnd_1
XFILLER_0_3_1213 VPWR VGND VPWR VGND sky130_ef_sc_hd__decap_12
XTAP_1744 VGND VPWR sky130_fd_sc_hd__tapvpwrvgnd_1
XTAP_1755 VGND VPWR sky130_fd_sc_hd__tapvpwrvgnd_1
XTAP_1799 VGND VPWR sky130_fd_sc_hd__tapvpwrvgnd_1
XTAP_1788 VGND VPWR sky130_fd_sc_hd__tapvpwrvgnd_1
XTAP_1777 VGND VPWR sky130_fd_sc_hd__tapvpwrvgnd_1
XFILLER_0_126_617 VGND VGND VPWR VPWR sky130_fd_sc_hd__fill_1
XANTENNA_input91_A psum_col1_in[3] VGND VGND VPWR VPWR sky130_fd_sc_hd__diode_2
XFILLER_0_148_1225 VGND VGND VPWR VPWR sky130_fd_sc_hd__fill_1
XFILLER_0_11_15 VPWR VGND VPWR VGND sky130_ef_sc_hd__decap_12
XFILLER_0_3_1257 VPWR VGND VPWR VGND sky130_ef_sc_hd__decap_12
XFILLER_0_14_1281 VGND VGND VPWR VPWR sky130_fd_sc_hd__fill_1
XFILLER_0_107_853 VPWR VGND VPWR VGND sky130_ef_sc_hd__decap_12
XFILLER_0_49_1311 VPWR VGND VPWR VGND sky130_ef_sc_hd__decap_12
XFILLER_0_84_1213 VPWR VGND VPWR VGND sky130_ef_sc_hd__decap_12
XFILLER_0_107_897 VPWR VGND VPWR VGND sky130_ef_sc_hd__decap_12
XFILLER_0_106_363 VGND VGND VPWR VPWR sky130_fd_sc_hd__fill_1
XFILLER_0_194_1201 VPWR VGND VPWR VGND sky130_ef_sc_hd__decap_12
XFILLER_0_159_1343 VGND VGND VPWR VPWR sky130_fd_sc_hd__fill_1
XFILLER_0_223_429 VPWR VGND VPWR VGND sky130_ef_sc_hd__decap_12
Xinput8 act_row0_in[1] VGND VGND VPWR VPWR net8 sky130_fd_sc_hd__clkbuf_4
XFILLER_0_127_47 VGND VGND VPWR VPWR sky130_fd_sc_hd__fill_1
XFILLER_0_204_643 VPWR VGND VPWR VGND sky130_ef_sc_hd__decap_12
XFILLER_0_56_1337 VGND VGND VPWR VPWR sky130_fd_sc_hd__fill_1
XFILLER_0_143_46 VGND VGND VPWR VPWR sky130_fd_sc_hd__decap_4
XFILLER_0_146_3 VPWR VGND VPWR VGND sky130_ef_sc_hd__decap_12
XFILLER_0_117_617 VPWR VGND VPWR VGND sky130_ef_sc_hd__decap_12
XFILLER_0_7_837 VGND VGND VPWR VPWR sky130_fd_sc_hd__decap_3
XFILLER_0_207_1311 VPWR VGND VPWR VGND sky130_ef_sc_hd__decap_12
XFILLER_0_127_1309 VGND VGND VPWR VPWR sky130_fd_sc_hd__fill_1
XANTENNA_u_pe01_weight_in[10] net118 VGND VGND VPWR VPWR sky130_fd_sc_hd__diode_2
XFILLER_0_140_631 VPWR VGND VPWR VGND sky130_ef_sc_hd__decap_12
XFILLER_0_2_531 VGND VGND VPWR VPWR sky130_fd_sc_hd__fill_1
XFILLER_0_112_333 VPWR VGND VPWR VGND sky130_ef_sc_hd__decap_12
XFILLER_0_113_889 VGND VGND VPWR VPWR sky130_fd_sc_hd__decap_6
XFILLER_0_168_10 VPWR VGND VPWR VGND sky130_ef_sc_hd__decap_12
XFILLER_0_112_377 VPWR VGND VPWR VGND sky130_ef_sc_hd__decap_12
XFILLER_0_226_278 VGND VGND VPWR VPWR sky130_fd_sc_hd__fill_2
XFILLER_0_214_1315 VGND VGND VPWR VPWR sky130_fd_sc_hd__fill_1
XFILLER_0_97_629 VPWR VGND VPWR VGND sky130_ef_sc_hd__decap_12
XFILLER_0_210_613 VGND VGND VPWR VPWR sky130_fd_sc_hd__decap_3
XFILLER_0_210_657 VPWR VGND VPWR VGND sky130_ef_sc_hd__decap_12
XPHY_816 VGND VGND VPWR VPWR sky130_fd_sc_hd__decap_3
XPHY_805 VGND VGND VPWR VPWR sky130_fd_sc_hd__decap_3
XPHY_827 VGND VGND VPWR VPWR sky130_fd_sc_hd__decap_3
XFILLER_0_212_1061 VPWR VGND VPWR VGND sky130_ef_sc_hd__decap_12
XPHY_838 VGND VGND VPWR VPWR sky130_fd_sc_hd__decap_3
XPHY_849 VGND VGND VPWR VPWR sky130_fd_sc_hd__decap_3
XFILLER_0_203_49 VGND VGND VPWR VPWR sky130_fd_sc_hd__fill_1
XFILLER_0_107_105 VGND VGND VPWR VPWR sky130_fd_sc_hd__decap_6
XFILLER_0_107_149 VPWR VGND VPWR VGND sky130_ef_sc_hd__decap_12
XFILLER_0_6_881 VPWR VGND VPWR VGND sky130_ef_sc_hd__decap_12
XFILLER_0_5_391 VGND VGND VPWR VPWR sky130_fd_sc_hd__fill_1
XFILLER_0_21_629 VPWR VGND VPWR VGND sky130_ef_sc_hd__decap_12
XFILLER_0_147_1291 VPWR VGND VPWR VGND sky130_ef_sc_hd__decap_12
XFILLER_0_108_1253 VGND VGND VPWR VPWR sky130_fd_sc_hd__decap_6
XFILLER_0_218_713 VPWR VGND VPWR VGND sky130_ef_sc_hd__decap_12
XFILLER_0_108_1297 VPWR VGND VPWR VGND sky130_ef_sc_hd__decap_12
XFILLER_0_104_1117 VGND VGND VPWR VPWR sky130_fd_sc_hd__decap_3
XFILLER_0_44_1263 VPWR VGND VPWR VGND sky130_ef_sc_hd__decap_12
XFILLER_0_218_757 VPWR VGND VPWR VGND sky130_ef_sc_hd__decap_12
XFILLER_0_217_223 VGND VGND VPWR VPWR sky130_fd_sc_hd__fill_1
XFILLER_0_198_631 VPWR VGND VPWR VGND sky130_ef_sc_hd__decap_12
XFILLER_0_154_1251 VPWR VGND VPWR VGND sky130_ef_sc_hd__decap_12
XFILLER_0_213_473 VPWR VGND VPWR VGND sky130_ef_sc_hd__decap_12
XTAP_2253 VGND VPWR sky130_fd_sc_hd__tapvpwrvgnd_1
XTAP_2231 VGND VPWR sky130_fd_sc_hd__tapvpwrvgnd_1
XTAP_2220 VGND VPWR sky130_fd_sc_hd__tapvpwrvgnd_1
XFILLER_0_115_1213 VPWR VGND VPWR VGND sky130_ef_sc_hd__decap_12
XTAP_2242 VGND VPWR sky130_fd_sc_hd__tapvpwrvgnd_1
XFILLER_0_189_1303 VGND VGND VPWR VPWR sky130_fd_sc_hd__decap_6
XFILLER_0_154_1295 VPWR VGND VPWR VGND sky130_ef_sc_hd__decap_12
XTAP_2275 VGND VPWR sky130_fd_sc_hd__tapvpwrvgnd_1
XTAP_2264 VGND VPWR sky130_fd_sc_hd__tapvpwrvgnd_1
XFILLER_0_90_1283 VPWR VGND VPWR VGND sky130_ef_sc_hd__decap_12
XTAP_2286 VGND VPWR sky130_fd_sc_hd__tapvpwrvgnd_1
XTAP_1541 VGND VPWR sky130_fd_sc_hd__tapvpwrvgnd_1
XTAP_1530 VGND VPWR sky130_fd_sc_hd__tapvpwrvgnd_1
XFILLER_0_51_1201 VPWR VGND VPWR VGND sky130_ef_sc_hd__decap_12
XFILLER_0_115_1279 VPWR VGND VPWR VGND sky130_ef_sc_hd__decap_12
XPHY_70 VGND VGND VPWR VPWR sky130_fd_sc_hd__decap_3
XTAP_1574 VGND VPWR sky130_fd_sc_hd__tapvpwrvgnd_1
XFILLER_0_3_1021 VPWR VGND VPWR VGND sky130_ef_sc_hd__decap_12
XPHY_81 VGND VGND VPWR VPWR sky130_fd_sc_hd__decap_3
XPHY_92 VGND VGND VPWR VPWR sky130_fd_sc_hd__decap_3
XTAP_1552 VGND VPWR sky130_fd_sc_hd__tapvpwrvgnd_1
XTAP_1563 VGND VPWR sky130_fd_sc_hd__tapvpwrvgnd_1
XTAP_1585 VGND VPWR sky130_fd_sc_hd__tapvpwrvgnd_1
XFILLER_0_51_1267 VPWR VGND VPWR VGND sky130_ef_sc_hd__decap_12
XFILLER_0_113_27 VPWR VGND VPWR VGND sky130_ef_sc_hd__decap_12
XTAP_2297 VGND VPWR sky130_fd_sc_hd__tapvpwrvgnd_1
XTAP_1596 VGND VPWR sky130_fd_sc_hd__tapvpwrvgnd_1
XFILLER_0_3_1065 VPWR VGND VPWR VGND sky130_ef_sc_hd__decap_12
XFILLER_0_86_1319 VPWR VGND VPWR VGND sky130_ef_sc_hd__decap_12
XFILLER_0_3_317 VPWR VGND VPWR VGND sky130_ef_sc_hd__decap_12
XFILLER_0_98_29 VPWR VGND VPWR VGND sky130_ef_sc_hd__decap_12
XFILLER_0_126_1331 VGND VGND VPWR VPWR sky130_fd_sc_hd__decap_6
XFILLER_0_122_631 VPWR VGND VPWR VGND sky130_ef_sc_hd__decap_12
XFILLER_0_161_1255 VPWR VGND VPWR VGND sky130_ef_sc_hd__decap_12
XFILLER_0_110_837 VPWR VGND VPWR VGND sky130_ef_sc_hd__decap_12
XFILLER_0_23_1303 VGND VGND VPWR VPWR sky130_fd_sc_hd__decap_6
XFILLER_0_196_1307 VPWR VGND VPWR VGND sky130_ef_sc_hd__decap_12
XFILLER_0_122_1239 VPWR VGND VPWR VGND sky130_ef_sc_hd__decap_12
XFILLER_0_202_1263 VPWR VGND VPWR VGND sky130_ef_sc_hd__decap_12
XFILLER_0_224_749 VGND VGND VPWR VPWR sky130_fd_sc_hd__decap_6
XFILLER_0_223_237 VPWR VGND VPWR VGND sky130_ef_sc_hd__decap_12
XFILLER_0_63_10 VPWR VGND VPWR VGND sky130_ef_sc_hd__decap_12
XFILLER_0_79_629 VPWR VGND VPWR VGND sky130_ef_sc_hd__decap_12
XFILLER_0_133_1335 VGND VGND VPWR VPWR sky130_fd_sc_hd__decap_8
XFILLER_0_30_1307 VPWR VGND VPWR VGND sky130_ef_sc_hd__decap_12
XFILLER_0_7_601 VPWR VGND VPWR VGND sky130_ef_sc_hd__decap_12
XFILLER_0_105_609 VGND VGND VPWR VPWR sky130_fd_sc_hd__decap_6
XFILLER_0_6_133 VGND VGND VPWR VPWR sky130_fd_sc_hd__decap_6
XFILLER_0_7_645 VPWR VGND VPWR VGND sky130_ef_sc_hd__decap_12
XFILLER_0_6_177 VPWR VGND VPWR VGND sky130_ef_sc_hd__decap_12
XFILLER_0_28_1225 VGND VGND VPWR VPWR sky130_fd_sc_hd__fill_1
XFILLER_0_113_653 VPWR VGND VPWR VGND sky130_ef_sc_hd__decap_12
XFILLER_0_112_141 VPWR VGND VPWR VGND sky130_ef_sc_hd__decap_12
XFILLER_0_113_697 VPWR VGND VPWR VGND sky130_ef_sc_hd__decap_12
XFILLER_0_3_895 VGND VGND VPWR VPWR sky130_fd_sc_hd__fill_1
XFILLER_0_220_1341 VGND VGND VPWR VPWR sky130_fd_sc_hd__fill_1
XFILLER_0_140_1339 VGND VGND VPWR VPWR sky130_fd_sc_hd__decap_4
Xoutput186 net186 VGND VGND VPWR VPWR psum_col0_out[29] sky130_fd_sc_hd__clkbuf_4
Xoutput175 net175 VGND VGND VPWR VPWR psum_col0_out[19] sky130_fd_sc_hd__clkbuf_4
Xoutput197 net197 VGND VGND VPWR VPWR psum_col1_out[0] sky130_fd_sc_hd__clkbuf_4
XFILLER_0_215_727 VGND VGND VPWR VPWR sky130_fd_sc_hd__fill_1
XFILLER_0_138_1213 VPWR VGND VPWR VGND sky130_ef_sc_hd__decap_12
XFILLER_0_74_1201 VPWR VGND VPWR VGND sky130_ef_sc_hd__decap_12
XFILLER_0_39_1343 VGND VGND VPWR VPWR sky130_fd_sc_hd__fill_1
XFILLER_0_211_933 VPWR VGND VPWR VGND sky130_ef_sc_hd__decap_12
XFILLER_0_210_421 VPWR VGND VPWR VGND sky130_ef_sc_hd__decap_12
XFILLER_0_211_977 VPWR VGND VPWR VGND sky130_ef_sc_hd__decap_12
XFILLER_0_195_645 VGND VGND VPWR VPWR sky130_fd_sc_hd__fill_1
XFILLER_0_214_15 VPWR VGND VPWR VGND sky130_ef_sc_hd__decap_12
XPHY_602 VGND VGND VPWR VPWR sky130_fd_sc_hd__decap_3
XFILLER_0_210_1009 VGND VGND VPWR VPWR sky130_fd_sc_hd__decap_4
XPHY_624 VGND VGND VPWR VPWR sky130_fd_sc_hd__decap_3
XPHY_613 VGND VGND VPWR VPWR sky130_fd_sc_hd__decap_3
XPHY_635 VGND VGND VPWR VPWR sky130_fd_sc_hd__decap_3
XPHY_1201 VGND VGND VPWR VPWR sky130_fd_sc_hd__decap_3
XPHY_1212 VGND VGND VPWR VPWR sky130_fd_sc_hd__decap_3
XPHY_646 VGND VGND VPWR VPWR sky130_fd_sc_hd__decap_3
XFILLER_0_4_1341 VGND VGND VPWR VPWR sky130_fd_sc_hd__decap_3
XPHY_657 VGND VGND VPWR VPWR sky130_fd_sc_hd__decap_3
XPHY_668 VGND VGND VPWR VPWR sky130_fd_sc_hd__decap_3
XPHY_679 VGND VGND VPWR VPWR sky130_fd_sc_hd__decap_3
XFILLER_0_0_1205 VGND VGND VPWR VPWR sky130_fd_sc_hd__decap_6
XFILLER_0_0_1227 VGND VGND VPWR VPWR sky130_fd_sc_hd__decap_3
XFILLER_0_108_469 VGND VGND VPWR VPWR sky130_fd_sc_hd__decap_6
XFILLER_0_0_309 VGND VGND VPWR VPWR sky130_fd_sc_hd__fill_2
XFILLER_0_108_1061 VPWR VGND VPWR VGND sky130_ef_sc_hd__decap_12
XFILLER_0_104_697 VGND VGND VPWR VPWR sky130_fd_sc_hd__decap_3
XFILLER_0_81_1249 VGND VGND VPWR VPWR sky130_fd_sc_hd__decap_4
XANTENNA_input54_A psum_col0_in[28] VGND VGND VPWR VPWR sky130_fd_sc_hd__diode_2
XFILLER_0_219_1001 VGND VGND VPWR VPWR sky130_fd_sc_hd__decap_6
XFILLER_0_218_587 VGND VGND VPWR VPWR sky130_fd_sc_hd__fill_1
XFILLER_0_219_1045 VPWR VGND VPWR VGND sky130_ef_sc_hd__decap_12
XFILLER_0_17_25 VPWR VGND VPWR VGND sky130_ef_sc_hd__decap_12
XFILLER_0_219_1089 VPWR VGND VPWR VGND sky130_ef_sc_hd__decap_12
XFILLER_0_191_1237 VPWR VGND VPWR VGND sky130_ef_sc_hd__decap_12
XFILLER_0_214_793 VPWR VGND VPWR VGND sky130_ef_sc_hd__decap_12
XANTENNA_output210_A net210 VGND VGND VPWR VPWR sky130_fd_sc_hd__diode_2
XFILLER_0_213_281 VPWR VGND VPWR VGND sky130_ef_sc_hd__decap_12
XTAP_2061 VGND VPWR sky130_fd_sc_hd__tapvpwrvgnd_1
XTAP_2050 VGND VPWR sky130_fd_sc_hd__tapvpwrvgnd_1
XFILLER_0_124_15 VPWR VGND VPWR VGND sky130_ef_sc_hd__decap_12
XTAP_2094 VGND VPWR sky130_fd_sc_hd__tapvpwrvgnd_1
XTAP_2083 VGND VPWR sky130_fd_sc_hd__tapvpwrvgnd_1
XTAP_2072 VGND VPWR sky130_fd_sc_hd__tapvpwrvgnd_1
XTAP_1382 VGND VPWR sky130_fd_sc_hd__tapvpwrvgnd_1
XTAP_1360 VGND VPWR sky130_fd_sc_hd__tapvpwrvgnd_1
XTAP_1371 VGND VPWR sky130_fd_sc_hd__tapvpwrvgnd_1
XTAP_1393 VGND VPWR sky130_fd_sc_hd__tapvpwrvgnd_1
XFILLER_0_84_643 VPWR VGND VPWR VGND sky130_ef_sc_hd__decap_12
XFILLER_0_108_981 VPWR VGND VPWR VGND sky130_ef_sc_hd__decap_12
Xinput11 act_row0_in[4] VGND VGND VPWR VPWR net11 sky130_fd_sc_hd__clkbuf_4
Xinput22 act_row1_in[14] VGND VGND VPWR VPWR net22 sky130_fd_sc_hd__buf_1
XFILLER_0_114_417 VGND VGND VPWR VPWR sky130_fd_sc_hd__decap_3
Xinput55 psum_col0_in[29] VGND VGND VPWR VPWR net55 sky130_fd_sc_hd__buf_1
Xinput44 psum_col0_in[19] VGND VGND VPWR VPWR net44 sky130_fd_sc_hd__buf_1
XFILLER_0_3_125 VPWR VGND VPWR VGND sky130_ef_sc_hd__decap_12
XFILLER_0_4_637 VGND VGND VPWR VPWR sky130_fd_sc_hd__decap_6
Xinput33 load_weight VGND VGND VPWR VPWR net33 sky130_fd_sc_hd__clkbuf_16
XFILLER_0_109_3 VPWR VGND VPWR VGND sky130_ef_sc_hd__decap_12
Xinput88 psum_col1_in[2] VGND VGND VPWR VPWR net88 sky130_fd_sc_hd__buf_1
Xinput77 psum_col1_in[1] VGND VGND VPWR VPWR net77 sky130_fd_sc_hd__buf_1
Xinput66 psum_col1_in[0] VGND VGND VPWR VPWR net66 sky130_fd_sc_hd__buf_1
XFILLER_0_3_169 VPWR VGND VPWR VGND sky130_ef_sc_hd__decap_12
XFILLER_0_110_601 VPWR VGND VPWR VGND sky130_ef_sc_hd__decap_12
Xinput99 valid_row0_in VGND VGND VPWR VPWR net99 sky130_fd_sc_hd__clkbuf_4
XFILLER_0_110_645 VPWR VGND VPWR VGND sky130_ef_sc_hd__decap_12
XFILLER_0_27_1291 VPWR VGND VPWR VGND sky130_ef_sc_hd__decap_12
XFILLER_0_97_1201 VPWR VGND VPWR VGND sky130_ef_sc_hd__decap_12
Xclkbuf_1_0__f_clk clknet_0_clk VGND VGND VPWR VPWR clknet_1_0__leaf_clk sky130_fd_sc_hd__clkbuf_16
XFILLER_0_224_513 VPWR VGND VPWR VGND sky130_ef_sc_hd__decap_12
XFILLER_0_97_1267 VPWR VGND VPWR VGND sky130_ef_sc_hd__decap_12
XFILLER_0_224_557 VPWR VGND VPWR VGND sky130_ef_sc_hd__decap_12
XFILLER_0_177_645 VGND VGND VPWR VPWR sky130_fd_sc_hd__fill_1
XFILLER_0_34_1251 VPWR VGND VPWR VGND sky130_ef_sc_hd__decap_12
XFILLER_0_90_41 VGND VGND VPWR VPWR sky130_fd_sc_hd__decap_8
XFILLER_0_168_1239 VPWR VGND VPWR VGND sky130_ef_sc_hd__decap_12
XFILLER_0_34_1295 VPWR VGND VPWR VGND sky130_ef_sc_hd__decap_12
XFILLER_0_69_1303 VGND VGND VPWR VPWR sky130_fd_sc_hd__decap_6
XFILLER_0_114_81 VGND VGND VPWR VPWR sky130_fd_sc_hd__decap_3
XFILLER_0_209_1225 VPWR VGND VPWR VGND sky130_ef_sc_hd__decap_12
XFILLER_0_105_417 VPWR VGND VPWR VGND sky130_ef_sc_hd__decap_12
XFILLER_0_105_1201 VPWR VGND VPWR VGND sky130_ef_sc_hd__decap_12
XFILLER_0_113_461 VPWR VGND VPWR VGND sky130_ef_sc_hd__decap_12
XFILLER_0_219_329 VGND VGND VPWR VPWR sky130_fd_sc_hd__decap_6
XFILLER_0_144_1283 VPWR VGND VPWR VGND sky130_ef_sc_hd__decap_12
XFILLER_0_105_1245 VPWR VGND VPWR VGND sky130_ef_sc_hd__decap_12
XFILLER_0_101_645 VGND VGND VPWR VPWR sky130_fd_sc_hd__fill_1
XFILLER_0_209_15 VPWR VGND VPWR VGND sky130_ef_sc_hd__decap_12
XFILLER_0_105_1289 VPWR VGND VPWR VGND sky130_ef_sc_hd__decap_12
XFILLER_0_41_1255 VPWR VGND VPWR VGND sky130_ef_sc_hd__decap_12
XFILLER_0_76_1307 VPWR VGND VPWR VGND sky130_ef_sc_hd__decap_12
XFILLER_0_216_1229 VPWR VGND VPWR VGND sky130_ef_sc_hd__decap_12
XFILLER_0_190_1281 VGND VGND VPWR VPWR sky130_fd_sc_hd__fill_1
XFILLER_0_211_741 VPWR VGND VPWR VGND sky130_ef_sc_hd__decap_12
XFILLER_0_225_69 VPWR VGND VPWR VGND sky130_ef_sc_hd__decap_12
XFILLER_0_211_785 VPWR VGND VPWR VGND sky130_ef_sc_hd__decap_12
XFILLER_0_112_1205 VPWR VGND VPWR VGND sky130_ef_sc_hd__decap_12
XPHY_410 VGND VGND VPWR VPWR sky130_fd_sc_hd__decap_3
XPHY_443 VGND VGND VPWR VPWR sky130_fd_sc_hd__decap_3
XFILLER_0_66_643 VPWR VGND VPWR VGND sky130_ef_sc_hd__decap_12
XPHY_421 VGND VGND VPWR VPWR sky130_fd_sc_hd__decap_3
XPHY_432 VGND VGND VPWR VPWR sky130_fd_sc_hd__decap_3
XFILLER_0_13_1335 VGND VGND VPWR VPWR sky130_fd_sc_hd__decap_8
XFILLER_0_186_1339 VGND VGND VPWR VPWR sky130_fd_sc_hd__decap_4
XPHY_1020 VGND VGND VPWR VPWR sky130_fd_sc_hd__decap_3
XPHY_1031 VGND VGND VPWR VPWR sky130_fd_sc_hd__decap_3
XPHY_454 VGND VGND VPWR VPWR sky130_fd_sc_hd__decap_3
XPHY_465 VGND VGND VPWR VPWR sky130_fd_sc_hd__decap_3
XPHY_476 VGND VGND VPWR VPWR sky130_fd_sc_hd__decap_3
XFILLER_0_108_233 VPWR VGND VPWR VGND sky130_ef_sc_hd__decap_12
XPHY_1042 VGND VGND VPWR VPWR sky130_fd_sc_hd__decap_3
XPHY_1064 VGND VGND VPWR VPWR sky130_fd_sc_hd__decap_3
XPHY_1053 VGND VGND VPWR VPWR sky130_fd_sc_hd__decap_3
XPHY_487 VGND VGND VPWR VPWR sky130_fd_sc_hd__decap_3
XPHY_498 VGND VGND VPWR VPWR sky130_fd_sc_hd__decap_3
XPHY_1086 VGND VGND VPWR VPWR sky130_fd_sc_hd__decap_3
XPHY_1075 VGND VGND VPWR VPWR sky130_fd_sc_hd__decap_3
XPHY_1097 VGND VGND VPWR VPWR sky130_fd_sc_hd__decap_3
XFILLER_0_0_1079 VGND VGND VPWR VPWR sky130_fd_sc_hd__fill_2
XFILLER_0_108_277 VPWR VGND VPWR VGND sky130_ef_sc_hd__decap_12
XFILLER_0_105_951 VGND VGND VPWR VPWR sky130_fd_sc_hd__fill_1
XFILLER_0_1_629 VPWR VGND VPWR VGND sky130_ef_sc_hd__decap_12
XFILLER_0_104_461 VPWR VGND VPWR VGND sky130_ef_sc_hd__decap_12
XFILLER_0_123_1323 VPWR VGND VPWR VGND sky130_ef_sc_hd__decap_12
XFILLER_0_0_139 VGND VGND VPWR VPWR sky130_fd_sc_hd__fill_1
XFILLER_0_219_841 VPWR VGND VPWR VGND sky130_ef_sc_hd__decap_12
XFILLER_0_28_13 VPWR VGND VPWR VGND sky130_ef_sc_hd__decap_12
XANTENNA_u_pe00_psum_in[0] net34 VGND VGND VPWR VPWR sky130_fd_sc_hd__diode_2
XFILLER_0_20_1339 VGND VGND VPWR VPWR sky130_fd_sc_hd__decap_4
XFILLER_0_221_505 VPWR VGND VPWR VGND sky130_ef_sc_hd__decap_12
XFILLER_0_18_1213 VPWR VGND VPWR VGND sky130_ef_sc_hd__decap_12
XFILLER_0_135_47 VGND VGND VPWR VPWR sky130_fd_sc_hd__decap_3
XFILLER_0_159_645 VGND VGND VPWR VPWR sky130_fd_sc_hd__fill_1
XFILLER_0_128_1201 VPWR VGND VPWR VGND sky130_ef_sc_hd__decap_12
XFILLER_0_4_401 VPWR VGND VPWR VGND sky130_ef_sc_hd__decap_12
XFILLER_0_114_225 VPWR VGND VPWR VGND sky130_ef_sc_hd__decap_12
XFILLER_0_4_445 VPWR VGND VPWR VGND sky130_ef_sc_hd__decap_12
XFILLER_0_111_921 VPWR VGND VPWR VGND sky130_ef_sc_hd__decap_12
XFILLER_0_4_489 VPWR VGND VPWR VGND sky130_ef_sc_hd__decap_12
XFILLER_0_111_965 VPWR VGND VPWR VGND sky130_ef_sc_hd__decap_12
XANTENNA_clkbuf_1_0__f_clk_A clknet_0_clk VGND VGND VPWR VPWR sky130_fd_sc_hd__diode_2
XFILLER_0_0_673 VPWR VGND VPWR VGND sky130_ef_sc_hd__decap_12
XFILLER_0_0_651 VPWR VGND VPWR VGND sky130_ef_sc_hd__decap_12
XFILLER_0_110_475 VGND VGND VPWR VPWR sky130_fd_sc_hd__fill_1
XFILLER_0_225_833 VGND VGND VPWR VPWR sky130_fd_sc_hd__decap_6
XFILLER_0_224_321 VPWR VGND VPWR VGND sky130_ef_sc_hd__decap_12
XFILLER_0_225_877 VPWR VGND VPWR VGND sky130_ef_sc_hd__decap_12
XFILLER_0_33_3 VPWR VGND VPWR VGND sky130_ef_sc_hd__decap_12
XFILLER_0_109_81 VPWR VGND VPWR VGND sky130_ef_sc_hd__decap_12
XTAP_2819 VGND VPWR sky130_fd_sc_hd__tapvpwrvgnd_1
XFILLER_0_224_365 VPWR VGND VPWR VGND sky130_ef_sc_hd__decap_12
XTAP_2808 VGND VPWR sky130_fd_sc_hd__tapvpwrvgnd_1
XANTENNA_u_pe11_act_in[4] act_10_out_11_in\[4\] VGND VGND VPWR VPWR sky130_fd_sc_hd__diode_2
XFILLER_0_135_1249 VGND VGND VPWR VPWR sky130_fd_sc_hd__decap_4
XFILLER_0_71_1237 VPWR VGND VPWR VGND sky130_ef_sc_hd__decap_12
XFILLER_0_48_643 VPWR VGND VPWR VGND sky130_ef_sc_hd__decap_12
XFILLER_0_211_27 VPWR VGND VPWR VGND sky130_ef_sc_hd__decap_12
XFILLER_0_106_737 VPWR VGND VPWR VGND sky130_ef_sc_hd__decap_12
XFILLER_0_105_225 VPWR VGND VPWR VGND sky130_ef_sc_hd__decap_12
XFILLER_0_181_1225 VPWR VGND VPWR VGND sky130_ef_sc_hd__decap_12
XFILLER_0_114_781 VGND VGND VPWR VPWR sky130_fd_sc_hd__decap_3
XFILLER_0_219_137 VPWR VGND VPWR VGND sky130_ef_sc_hd__decap_12
XFILLER_0_216_811 VGND VGND VPWR VPWR sky130_fd_sc_hd__fill_1
XANTENNA_input156_A w11[1] VGND VGND VPWR VPWR sky130_fd_sc_hd__diode_2
XFILLER_0_192_1343 VGND VGND VPWR VPWR sky130_fd_sc_hd__fill_1
XANTENNA_input17_A act_row1_in[0] VGND VGND VPWR VPWR sky130_fd_sc_hd__diode_2
XFILLER_0_216_1037 VPWR VGND VPWR VGND sky130_ef_sc_hd__decap_12
XFILLER_0_112_1035 VGND VGND VPWR VPWR sky130_fd_sc_hd__fill_1
XPHY_251 VGND VGND VPWR VPWR sky130_fd_sc_hd__decap_3
XPHY_240 VGND VGND VPWR VPWR sky130_fd_sc_hd__decap_3
XFILLER_0_171_629 VPWR VGND VPWR VGND sky130_ef_sc_hd__decap_12
XFILLER_0_109_553 VGND VGND VPWR VPWR sky130_fd_sc_hd__decap_6
XPHY_262 VGND VGND VPWR VPWR sky130_fd_sc_hd__decap_3
XPHY_295 VGND VGND VPWR VPWR sky130_fd_sc_hd__decap_3
XPHY_273 VGND VGND VPWR VPWR sky130_fd_sc_hd__decap_3
XPHY_284 VGND VGND VPWR VPWR sky130_fd_sc_hd__decap_3
XFILLER_0_121_27 VPWR VGND VPWR VGND sky130_ef_sc_hd__decap_12
XFILLER_0_109_597 VPWR VGND VPWR VGND sky130_ef_sc_hd__decap_12
XFILLER_0_87_1255 VPWR VGND VPWR VGND sky130_ef_sc_hd__decap_12
XFILLER_0_2_905 VPWR VGND VPWR VGND sky130_ef_sc_hd__decap_12
XFILLER_0_48_1239 VPWR VGND VPWR VGND sky130_ef_sc_hd__decap_12
XFILLER_0_2_949 VPWR VGND VPWR VGND sky130_ef_sc_hd__decap_12
XFILLER_0_111_217 VGND VGND VPWR VPWR sky130_fd_sc_hd__decap_6
XFILLER_0_219_671 VGND VGND VPWR VPWR sky130_fd_sc_hd__fill_1
XFILLER_0_158_1227 VPWR VGND VPWR VGND sky130_ef_sc_hd__decap_12
XFILLER_0_24_1283 VPWR VGND VPWR VGND sky130_ef_sc_hd__decap_12
XFILLER_0_176_3 VPWR VGND VPWR VGND sky130_ef_sc_hd__decap_12
XFILLER_0_59_1335 VGND VGND VPWR VPWR sky130_fd_sc_hd__fill_1
XFILLER_0_222_825 VPWR VGND VPWR VGND sky130_ef_sc_hd__decap_12
XFILLER_0_222_869 VPWR VGND VPWR VGND sky130_ef_sc_hd__decap_12
XFILLER_0_221_335 VGND VGND VPWR VPWR sky130_fd_sc_hd__fill_1
XFILLER_0_202_593 VPWR VGND VPWR VGND sky130_ef_sc_hd__decap_12
XFILLER_0_169_1323 VPWR VGND VPWR VGND sky130_ef_sc_hd__decap_12
XFILLER_0_70_1281 VGND VGND VPWR VPWR sky130_fd_sc_hd__fill_1
XFILLER_0_5_721 VGND VGND VPWR VPWR sky130_fd_sc_hd__decap_6
XFILLER_0_60_605 VPWR VGND VPWR VGND sky130_ef_sc_hd__decap_12
XFILLER_0_5_765 VPWR VGND VPWR VGND sky130_ef_sc_hd__decap_12
XFILLER_0_66_1339 VGND VGND VPWR VPWR sky130_fd_sc_hd__decap_4
XFILLER_0_206_1239 VPWR VGND VPWR VGND sky130_ef_sc_hd__decap_12
XFILLER_0_4_253 VPWR VGND VPWR VGND sky130_ef_sc_hd__decap_12
XFILLER_0_111_93 VPWR VGND VPWR VGND sky130_ef_sc_hd__decap_12
XFILLER_0_141_1253 VGND VGND VPWR VPWR sky130_fd_sc_hd__fill_1
XANTENNA_input9_A act_row0_in[2] VGND VGND VPWR VPWR sky130_fd_sc_hd__diode_2
XFILLER_0_225_641 VPWR VGND VPWR VGND sky130_ef_sc_hd__decap_12
XFILLER_0_217_1313 VPWR VGND VPWR VGND sky130_ef_sc_hd__decap_12
XFILLER_0_225_685 VPWR VGND VPWR VGND sky130_ef_sc_hd__decap_12
XTAP_2605 VGND VPWR sky130_fd_sc_hd__tapvpwrvgnd_1
XTAP_2627 VGND VPWR sky130_fd_sc_hd__tapvpwrvgnd_1
XFILLER_0_224_195 VGND VGND VPWR VPWR sky130_fd_sc_hd__fill_1
XTAP_2616 VGND VPWR sky130_fd_sc_hd__tapvpwrvgnd_1
XFILLER_0_206_49 VGND VGND VPWR VPWR sky130_fd_sc_hd__fill_1
XTAP_2649 VGND VPWR sky130_fd_sc_hd__tapvpwrvgnd_1
XTAP_2638 VGND VPWR sky130_fd_sc_hd__tapvpwrvgnd_1
XFILLER_0_212_357 VGND VGND VPWR VPWR sky130_fd_sc_hd__decap_6
XTAP_1904 VGND VPWR sky130_fd_sc_hd__tapvpwrvgnd_1
XTAP_1915 VGND VPWR sky130_fd_sc_hd__tapvpwrvgnd_1
XFILLER_0_113_1333 VGND VGND VPWR VPWR sky130_fd_sc_hd__decap_3
XTAP_1948 VGND VPWR sky130_fd_sc_hd__tapvpwrvgnd_1
XTAP_1926 VGND VPWR sky130_fd_sc_hd__tapvpwrvgnd_1
XTAP_1937 VGND VPWR sky130_fd_sc_hd__tapvpwrvgnd_1
XTAP_1959 VGND VPWR sky130_fd_sc_hd__tapvpwrvgnd_1
XFILLER_0_222_15 VPWR VGND VPWR VGND sky130_ef_sc_hd__decap_12
XFILLER_0_153_629 VPWR VGND VPWR VGND sky130_ef_sc_hd__decap_12
XFILLER_0_183_1309 VGND VGND VPWR VPWR sky130_fd_sc_hd__fill_1
XFILLER_0_106_501 VPWR VGND VPWR VGND sky130_ef_sc_hd__decap_12
XFILLER_0_51_605 VPWR VGND VPWR VGND sky130_ef_sc_hd__decap_12
XFILLER_0_106_545 VPWR VGND VPWR VGND sky130_ef_sc_hd__decap_12
XFILLER_0_224_1317 VPWR VGND VPWR VGND sky130_ef_sc_hd__decap_12
XFILLER_0_106_589 VPWR VGND VPWR VGND sky130_ef_sc_hd__decap_12
XANTENNA_u_pe10_weight_in[13] net137 VGND VGND VPWR VPWR sky130_fd_sc_hd__diode_2
XFILLER_0_222_1085 VGND VGND VPWR VPWR sky130_fd_sc_hd__decap_6
XFILLER_0_208_619 VPWR VGND VPWR VGND sky130_ef_sc_hd__decap_12
XFILLER_0_120_1337 VGND VGND VPWR VPWR sky130_fd_sc_hd__fill_1
XFILLER_0_116_27 VGND VGND VPWR VPWR sky130_fd_sc_hd__fill_1
XFILLER_0_116_49 VGND VGND VPWR VPWR sky130_fd_sc_hd__fill_1
XFILLER_0_25_47 VGND VGND VPWR VPWR sky130_fd_sc_hd__fill_1
XFILLER_0_8_1339 VGND VGND VPWR VPWR sky130_fd_sc_hd__decap_4
XFILLER_0_15_1249 VGND VGND VPWR VPWR sky130_fd_sc_hd__decap_4
XFILLER_0_132_15 VPWR VGND VPWR VGND sky130_ef_sc_hd__decap_12
XFILLER_0_6_1085 VGND VGND VPWR VPWR sky130_fd_sc_hd__decap_6
XFILLER_0_42_605 VPWR VGND VPWR VGND sky130_ef_sc_hd__decap_12
XFILLER_0_109_361 VPWR VGND VPWR VGND sky130_ef_sc_hd__decap_12
XANTENNA_u_pe01_act_in[7] act_00_out_01_in\[7\] VGND VGND VPWR VPWR sky130_fd_sc_hd__diode_2
XFILLER_0_2_713 VPWR VGND VPWR VGND sky130_ef_sc_hd__decap_12
XFILLER_0_164_1275 VGND VGND VPWR VPWR sky130_fd_sc_hd__decap_6
XFILLER_0_125_1237 VPWR VGND VPWR VGND sky130_ef_sc_hd__decap_12
XFILLER_0_2_757 VPWR VGND VPWR VGND sky130_ef_sc_hd__decap_12
XFILLER_0_1_223 VGND VGND VPWR VPWR sky130_fd_sc_hd__fill_1
XFILLER_0_61_1225 VPWR VGND VPWR VGND sky130_ef_sc_hd__decap_12
XFILLER_0_66_10 VPWR VGND VPWR VGND sky130_ef_sc_hd__decap_12
XFILLER_0_5_57 VPWR VGND VPWR VGND sky130_ef_sc_hd__decap_12
XFILLER_0_157_34 VPWR VGND VPWR VGND sky130_ef_sc_hd__decap_12
XFILLER_0_207_641 VGND VGND VPWR VPWR sky130_fd_sc_hd__decap_4
XFILLER_0_226_449 VPWR VGND VPWR VGND sky130_ef_sc_hd__decap_12
XFILLER_0_171_1213 VPWR VGND VPWR VGND sky130_ef_sc_hd__decap_12
XFILLER_0_222_699 VGND VGND VPWR VPWR sky130_fd_sc_hd__fill_1
XFILLER_0_171_1279 VPWR VGND VPWR VGND sky130_ef_sc_hd__decap_12
XFILLER_0_72_1343 VGND VGND VPWR VPWR sky130_fd_sc_hd__fill_1
XFILLER_0_135_629 VPWR VGND VPWR VGND sky130_ef_sc_hd__decap_12
XFILLER_0_33_605 VPWR VGND VPWR VGND sky130_ef_sc_hd__decap_12
XFILLER_0_182_1331 VGND VGND VPWR VPWR sky130_fd_sc_hd__decap_6
XFILLER_0_198_41 VGND VGND VPWR VPWR sky130_fd_sc_hd__decap_8
XFILLER_0_5_573 VPWR VGND VPWR VGND sky130_ef_sc_hd__decap_12
XFILLER_0_218_917 VGND VGND VPWR VPWR sky130_fd_sc_hd__decap_6
XFILLER_0_217_405 VPWR VGND VPWR VGND sky130_ef_sc_hd__decap_12
XFILLER_0_217_449 VPWR VGND VPWR VGND sky130_ef_sc_hd__decap_12
XFILLER_0_217_37 VPWR VGND VPWR VGND sky130_ef_sc_hd__decap_12
XFILLER_0_217_1121 VPWR VGND VPWR VGND sky130_ef_sc_hd__decap_12
XTAP_2402 VGND VPWR sky130_fd_sc_hd__tapvpwrvgnd_1
XFILLER_0_212_121 VPWR VGND VPWR VGND sky130_ef_sc_hd__decap_12
XFILLER_0_38_1227 VPWR VGND VPWR VGND sky130_ef_sc_hd__decap_12
XFILLER_0_213_1007 VGND VGND VPWR VPWR sky130_fd_sc_hd__fill_1
XTAP_2435 VGND VPWR sky130_fd_sc_hd__tapvpwrvgnd_1
XTAP_2424 VGND VPWR sky130_fd_sc_hd__tapvpwrvgnd_1
XTAP_2413 VGND VPWR sky130_fd_sc_hd__tapvpwrvgnd_1
XTAP_2468 VGND VPWR sky130_fd_sc_hd__tapvpwrvgnd_1
XTAP_2446 VGND VPWR sky130_fd_sc_hd__tapvpwrvgnd_1
XFILLER_0_212_165 VPWR VGND VPWR VGND sky130_ef_sc_hd__decap_12
XTAP_2457 VGND VPWR sky130_fd_sc_hd__tapvpwrvgnd_1
XFILLER_0_150_1319 VPWR VGND VPWR VGND sky130_ef_sc_hd__decap_12
XANTENNA_input119_A w01[11] VGND VGND VPWR VPWR sky130_fd_sc_hd__diode_2
XTAP_1701 VGND VPWR sky130_fd_sc_hd__tapvpwrvgnd_1
XTAP_1734 VGND VPWR sky130_fd_sc_hd__tapvpwrvgnd_1
XTAP_1712 VGND VPWR sky130_fd_sc_hd__tapvpwrvgnd_1
XTAP_1723 VGND VPWR sky130_fd_sc_hd__tapvpwrvgnd_1
XTAP_2479 VGND VPWR sky130_fd_sc_hd__tapvpwrvgnd_1
XTAP_1745 VGND VPWR sky130_fd_sc_hd__tapvpwrvgnd_1
XTAP_1756 VGND VPWR sky130_fd_sc_hd__tapvpwrvgnd_1
XTAP_1767 VGND VPWR sky130_fd_sc_hd__tapvpwrvgnd_1
XTAP_1778 VGND VPWR sky130_fd_sc_hd__tapvpwrvgnd_1
XFILLER_0_3_1225 VGND VGND VPWR VPWR sky130_fd_sc_hd__decap_6
XTAP_1789 VGND VPWR sky130_fd_sc_hd__tapvpwrvgnd_1
XFILLER_0_187_1253 VGND VGND VPWR VPWR sky130_fd_sc_hd__fill_1
XFILLER_0_107_821 VPWR VGND VPWR VGND sky130_ef_sc_hd__decap_12
XFILLER_0_3_1269 VPWR VGND VPWR VGND sky130_ef_sc_hd__decap_12
XANTENNA_input84_A psum_col1_in[26] VGND VGND VPWR VPWR sky130_fd_sc_hd__diode_2
XFILLER_0_107_865 VPWR VGND VPWR VGND sky130_ef_sc_hd__decap_12
XFILLER_0_11_27 VPWR VGND VPWR VGND sky130_ef_sc_hd__decap_12
XFILLER_0_24_605 VPWR VGND VPWR VGND sky130_ef_sc_hd__decap_12
XFILLER_0_49_1323 VPWR VGND VPWR VGND sky130_ef_sc_hd__decap_12
XFILLER_0_102_29 VPWR VGND VPWR VGND sky130_ef_sc_hd__decap_12
XFILLER_0_91_593 VPWR VGND VPWR VGND sky130_ef_sc_hd__decap_12
XFILLER_0_84_1225 VGND VGND VPWR VPWR sky130_fd_sc_hd__fill_1
XFILLER_0_224_1147 VGND VGND VPWR VPWR sky130_fd_sc_hd__fill_1
XFILLER_0_159_1311 VPWR VGND VPWR VGND sky130_ef_sc_hd__decap_12
XFILLER_0_124_1281 VGND VGND VPWR VPWR sky130_fd_sc_hd__fill_1
XFILLER_0_194_1213 VPWR VGND VPWR VGND sky130_ef_sc_hd__decap_12
XFILLER_0_21_1253 VGND VGND VPWR VPWR sky130_fd_sc_hd__fill_1
XFILLER_0_127_15 VPWR VGND VPWR VGND sky130_ef_sc_hd__decap_12
Xinput9 act_row0_in[2] VGND VGND VPWR VPWR net9 sky130_fd_sc_hd__clkbuf_4
XFILLER_0_204_655 VGND VGND VPWR VPWR sky130_fd_sc_hd__decap_4
XFILLER_0_139_3 VPWR VGND VPWR VGND sky130_ef_sc_hd__decap_12
XFILLER_0_117_629 VPWR VGND VPWR VGND sky130_ef_sc_hd__decap_12
XFILLER_0_166_1337 VGND VGND VPWR VPWR sky130_fd_sc_hd__fill_1
XFILLER_0_15_605 VPWR VGND VPWR VGND sky130_ef_sc_hd__decap_12
XFILLER_0_207_1323 VPWR VGND VPWR VGND sky130_ef_sc_hd__decap_12
XFILLER_0_82_593 VPWR VGND VPWR VGND sky130_ef_sc_hd__decap_12
XFILLER_0_140_643 VPWR VGND VPWR VGND sky130_ef_sc_hd__decap_12
XFILLER_0_30_619 VPWR VGND VPWR VGND sky130_ef_sc_hd__decap_12
XFILLER_0_63_1309 VGND VGND VPWR VPWR sky130_fd_sc_hd__fill_1
XFILLER_0_112_301 VGND VGND VPWR VPWR sky130_fd_sc_hd__decap_6
XFILLER_0_112_345 VPWR VGND VPWR VGND sky130_ef_sc_hd__decap_12
XFILLER_0_168_22 VGND VGND VPWR VPWR sky130_fd_sc_hd__decap_6
XFILLER_0_2_587 VGND VGND VPWR VPWR sky130_fd_sc_hd__fill_1
XFILLER_0_112_389 VPWR VGND VPWR VGND sky130_ef_sc_hd__decap_12
XFILLER_0_103_1343 VGND VGND VPWR VPWR sky130_fd_sc_hd__fill_1
XFILLER_0_215_909 VPWR VGND VPWR VGND sky130_ef_sc_hd__decap_12
XFILLER_0_214_419 VGND VGND VPWR VPWR sky130_fd_sc_hd__fill_1
XFILLER_0_223_953 VPWR VGND VPWR VGND sky130_ef_sc_hd__decap_12
XFILLER_0_210_669 VGND VGND VPWR VPWR sky130_fd_sc_hd__decap_3
XPHY_817 VGND VGND VPWR VPWR sky130_fd_sc_hd__decap_3
XPHY_806 VGND VGND VPWR VPWR sky130_fd_sc_hd__decap_3
XFILLER_0_212_1073 VPWR VGND VPWR VGND sky130_ef_sc_hd__decap_12
XPHY_828 VGND VGND VPWR VPWR sky130_fd_sc_hd__decap_3
XPHY_839 VGND VGND VPWR VPWR sky130_fd_sc_hd__decap_3
XFILLER_0_104_813 VPWR VGND VPWR VGND sky130_ef_sc_hd__decap_12
XFILLER_0_73_593 VPWR VGND VPWR VGND sky130_ef_sc_hd__decap_12
XFILLER_0_6_893 VPWR VGND VPWR VGND sky130_ef_sc_hd__decap_12
XFILLER_0_83_1291 VPWR VGND VPWR VGND sky130_ef_sc_hd__decap_12
XFILLER_0_218_725 VPWR VGND VPWR VGND sky130_ef_sc_hd__decap_12
XFILLER_0_44_1275 VGND VGND VPWR VPWR sky130_fd_sc_hd__decap_6
XFILLER_0_218_769 VPWR VGND VPWR VGND sky130_ef_sc_hd__decap_12
XFILLER_0_217_279 VGND VGND VPWR VPWR sky130_fd_sc_hd__fill_1
XFILLER_0_198_643 VPWR VGND VPWR VGND sky130_ef_sc_hd__decap_12
XFILLER_0_213_441 VGND VGND VPWR VPWR sky130_fd_sc_hd__decap_6
XTAP_2210 VGND VPWR sky130_fd_sc_hd__tapvpwrvgnd_1
XFILLER_0_88_619 VPWR VGND VPWR VGND sky130_ef_sc_hd__decap_12
XFILLER_0_213_485 VPWR VGND VPWR VGND sky130_ef_sc_hd__decap_12
XFILLER_0_154_1263 VPWR VGND VPWR VGND sky130_ef_sc_hd__decap_12
XTAP_2243 VGND VPWR sky130_fd_sc_hd__tapvpwrvgnd_1
XTAP_2232 VGND VPWR sky130_fd_sc_hd__tapvpwrvgnd_1
XTAP_2221 VGND VPWR sky130_fd_sc_hd__tapvpwrvgnd_1
XFILLER_0_115_1225 VPWR VGND VPWR VGND sky130_ef_sc_hd__decap_12
XFILLER_0_201_647 VPWR VGND VPWR VGND sky130_ef_sc_hd__decap_12
XTAP_2287 VGND VPWR sky130_fd_sc_hd__tapvpwrvgnd_1
XTAP_2276 VGND VPWR sky130_fd_sc_hd__tapvpwrvgnd_1
XFILLER_0_90_1251 VPWR VGND VPWR VGND sky130_ef_sc_hd__decap_12
XTAP_2254 VGND VPWR sky130_fd_sc_hd__tapvpwrvgnd_1
XTAP_1542 VGND VPWR sky130_fd_sc_hd__tapvpwrvgnd_1
XTAP_1520 VGND VPWR sky130_fd_sc_hd__tapvpwrvgnd_1
XTAP_1531 VGND VPWR sky130_fd_sc_hd__tapvpwrvgnd_1
XFILLER_0_51_1213 VPWR VGND VPWR VGND sky130_ef_sc_hd__decap_12
XTAP_2265 VGND VPWR sky130_fd_sc_hd__tapvpwrvgnd_1
XFILLER_0_90_1295 VPWR VGND VPWR VGND sky130_ef_sc_hd__decap_12
XTAP_2298 VGND VPWR sky130_fd_sc_hd__tapvpwrvgnd_1
XFILLER_0_22_15 VPWR VGND VPWR VGND sky130_ef_sc_hd__decap_12
XPHY_82 VGND VGND VPWR VPWR sky130_fd_sc_hd__decap_3
XPHY_71 VGND VGND VPWR VPWR sky130_fd_sc_hd__decap_3
XPHY_60 VGND VGND VPWR VPWR sky130_fd_sc_hd__decap_3
XTAP_1553 VGND VPWR sky130_fd_sc_hd__tapvpwrvgnd_1
XTAP_1564 VGND VPWR sky130_fd_sc_hd__tapvpwrvgnd_1
XTAP_1575 VGND VPWR sky130_fd_sc_hd__tapvpwrvgnd_1
XTAP_1597 VGND VPWR sky130_fd_sc_hd__tapvpwrvgnd_1
XTAP_1586 VGND VPWR sky130_fd_sc_hd__tapvpwrvgnd_1
XFILLER_0_3_1033 VPWR VGND VPWR VGND sky130_ef_sc_hd__decap_12
XPHY_93 VGND VGND VPWR VPWR sky130_fd_sc_hd__decap_3
XFILLER_0_51_1279 VPWR VGND VPWR VGND sky130_ef_sc_hd__decap_12
XFILLER_0_113_39 VPWR VGND VPWR VGND sky130_ef_sc_hd__decap_12
XFILLER_0_3_1077 VPWR VGND VPWR VGND sky130_ef_sc_hd__decap_12
XFILLER_0_109_1007 VGND VGND VPWR VPWR sky130_fd_sc_hd__fill_1
XFILLER_0_107_673 VPWR VGND VPWR VGND sky130_ef_sc_hd__decap_12
XFILLER_0_64_593 VPWR VGND VPWR VGND sky130_ef_sc_hd__decap_12
XFILLER_0_161_1201 VPWR VGND VPWR VGND sky130_ef_sc_hd__decap_12
XFILLER_0_3_329 VGND VGND VPWR VPWR sky130_fd_sc_hd__decap_6
XFILLER_0_12_619 VPWR VGND VPWR VGND sky130_ef_sc_hd__decap_12
XFILLER_0_126_1343 VGND VGND VPWR VPWR sky130_fd_sc_hd__fill_1
XFILLER_0_122_643 VPWR VGND VPWR VGND sky130_ef_sc_hd__decap_12
XFILLER_0_110_805 VGND VGND VPWR VPWR sky130_fd_sc_hd__decap_6
XFILLER_0_161_1267 VPWR VGND VPWR VGND sky130_ef_sc_hd__decap_12
XFILLER_0_110_849 VPWR VGND VPWR VGND sky130_ef_sc_hd__decap_12
XFILLER_0_62_1331 VGND VGND VPWR VPWR sky130_fd_sc_hd__decap_6
XFILLER_0_196_1319 VPWR VGND VPWR VGND sky130_ef_sc_hd__decap_12
XFILLER_0_202_1275 VGND VGND VPWR VPWR sky130_fd_sc_hd__decap_6
XFILLER_0_223_205 VPWR VGND VPWR VGND sky130_ef_sc_hd__decap_12
XFILLER_0_223_249 VPWR VGND VPWR VGND sky130_ef_sc_hd__decap_12
XFILLER_0_63_22 VPWR VGND VPWR VGND sky130_ef_sc_hd__decap_12
XFILLER_0_220_923 VGND VGND VPWR VPWR sky130_fd_sc_hd__fill_1
XFILLER_0_133_1303 VGND VGND VPWR VPWR sky130_fd_sc_hd__decap_6
XFILLER_0_87_641 VGND VGND VPWR VPWR sky130_fd_sc_hd__decap_4
XFILLER_0_7_613 VGND VGND VPWR VPWR sky130_fd_sc_hd__decap_3
XFILLER_0_30_1319 VPWR VGND VPWR VGND sky130_ef_sc_hd__decap_12
XFILLER_0_7_657 VPWR VGND VPWR VGND sky130_ef_sc_hd__decap_12
XFILLER_0_55_593 VPWR VGND VPWR VGND sky130_ef_sc_hd__decap_12
XFILLER_0_104_109 VGND VGND VPWR VPWR sky130_fd_sc_hd__decap_3
XFILLER_0_6_189 VGND VGND VPWR VPWR sky130_fd_sc_hd__decap_6
XFILLER_0_67_1253 VGND VGND VPWR VPWR sky130_fd_sc_hd__fill_1
XFILLER_0_113_665 VGND VGND VPWR VPWR sky130_fd_sc_hd__decap_6
XFILLER_0_3_841 VPWR VGND VPWR VGND sky130_ef_sc_hd__decap_12
XFILLER_0_88_41 VGND VGND VPWR VPWR sky130_fd_sc_hd__decap_8
XFILLER_0_140_1307 VPWR VGND VPWR VGND sky130_ef_sc_hd__decap_12
XFILLER_0_11_641 VGND VGND VPWR VPWR sky130_fd_sc_hd__decap_4
XFILLER_0_112_153 VPWR VGND VPWR VGND sky130_ef_sc_hd__decap_12
Xoutput176 net176 VGND VGND VPWR VPWR psum_col0_out[1] sky130_fd_sc_hd__clkbuf_4
Xoutput165 net165 VGND VGND VPWR VPWR psum_col0_out[0] sky130_fd_sc_hd__clkbuf_4
XFILLER_0_112_197 VPWR VGND VPWR VGND sky130_ef_sc_hd__decap_12
Xoutput198 net198 VGND VGND VPWR VPWR psum_col1_out[10] sky130_fd_sc_hd__clkbuf_4
Xoutput187 net187 VGND VGND VPWR VPWR psum_col0_out[2] sky130_fd_sc_hd__clkbuf_4
XFILLER_0_138_1225 VGND VGND VPWR VPWR sky130_fd_sc_hd__fill_1
XFILLER_0_39_1311 VPWR VGND VPWR VGND sky130_ef_sc_hd__decap_12
XFILLER_0_74_1213 VPWR VGND VPWR VGND sky130_ef_sc_hd__decap_12
XFILLER_0_223_783 VGND VGND VPWR VPWR sky130_fd_sc_hd__fill_1
XFILLER_0_211_945 VGND VGND VPWR VPWR sky130_fd_sc_hd__decap_6
XFILLER_0_214_27 VGND VGND VPWR VPWR sky130_fd_sc_hd__fill_1
XFILLER_0_210_433 VPWR VGND VPWR VGND sky130_ef_sc_hd__decap_12
XFILLER_0_211_989 VPWR VGND VPWR VGND sky130_ef_sc_hd__decap_12
XFILLER_0_210_477 VGND VGND VPWR VPWR sky130_fd_sc_hd__fill_2
XPHY_625 VGND VGND VPWR VPWR sky130_fd_sc_hd__decap_3
XPHY_603 VGND VGND VPWR VPWR sky130_fd_sc_hd__decap_3
XPHY_614 VGND VGND VPWR VPWR sky130_fd_sc_hd__decap_3
XPHY_1213 VGND VGND VPWR VPWR sky130_fd_sc_hd__decap_3
XPHY_1202 VGND VGND VPWR VPWR sky130_fd_sc_hd__decap_3
XPHY_636 VGND VGND VPWR VPWR sky130_fd_sc_hd__decap_3
XPHY_658 VGND VGND VPWR VPWR sky130_fd_sc_hd__decap_3
XPHY_647 VGND VGND VPWR VPWR sky130_fd_sc_hd__decap_3
XPHY_669 VGND VGND VPWR VPWR sky130_fd_sc_hd__decap_3
XFILLER_0_184_1201 VPWR VGND VPWR VGND sky130_ef_sc_hd__decap_12
XFILLER_0_46_593 VPWR VGND VPWR VGND sky130_ef_sc_hd__decap_12
XFILLER_0_225_1231 VGND VGND VPWR VPWR sky130_fd_sc_hd__fill_1
XFILLER_0_46_1337 VGND VGND VPWR VPWR sky130_fd_sc_hd__fill_1
XFILLER_0_108_1073 VPWR VGND VPWR VGND sky130_ef_sc_hd__decap_12
XFILLER_0_218_533 VPWR VGND VPWR VGND sky130_ef_sc_hd__decap_12
XANTENNA_input47_A psum_col0_in[21] VGND VGND VPWR VPWR sky130_fd_sc_hd__diode_2
XFILLER_0_17_37 VPWR VGND VPWR VGND sky130_ef_sc_hd__decap_12
XFILLER_0_219_1057 VGND VGND VPWR VPWR sky130_fd_sc_hd__decap_6
XFILLER_0_191_1249 VGND VGND VPWR VPWR sky130_fd_sc_hd__decap_4
XFILLER_0_221_709 VPWR VGND VPWR VGND sky130_ef_sc_hd__decap_12
XFILLER_0_117_1309 VGND VGND VPWR VPWR sky130_fd_sc_hd__fill_1
XFILLER_0_213_293 VPWR VGND VPWR VGND sky130_ef_sc_hd__decap_12
XTAP_2040 VGND VPWR sky130_fd_sc_hd__tapvpwrvgnd_1
XFILLER_0_69_641 VGND VGND VPWR VPWR sky130_fd_sc_hd__decap_4
XFILLER_0_9_1253 VGND VGND VPWR VPWR sky130_fd_sc_hd__fill_1
XTAP_2051 VGND VPWR sky130_fd_sc_hd__tapvpwrvgnd_1
XFILLER_0_124_27 VGND VGND VPWR VPWR sky130_fd_sc_hd__fill_1
XTAP_2084 VGND VPWR sky130_fd_sc_hd__tapvpwrvgnd_1
XTAP_2062 VGND VPWR sky130_fd_sc_hd__tapvpwrvgnd_1
XFILLER_0_33_47 VGND VGND VPWR VPWR sky130_fd_sc_hd__fill_1
XTAP_1350 VGND VPWR sky130_fd_sc_hd__tapvpwrvgnd_1
XTAP_2073 VGND VPWR sky130_fd_sc_hd__tapvpwrvgnd_1
XTAP_2095 VGND VPWR sky130_fd_sc_hd__tapvpwrvgnd_1
XFILLER_0_124_49 VGND VGND VPWR VPWR sky130_fd_sc_hd__fill_1
XTAP_1361 VGND VPWR sky130_fd_sc_hd__tapvpwrvgnd_1
XTAP_1383 VGND VPWR sky130_fd_sc_hd__tapvpwrvgnd_1
XTAP_1372 VGND VPWR sky130_fd_sc_hd__tapvpwrvgnd_1
XFILLER_0_84_655 VGND VGND VPWR VPWR sky130_fd_sc_hd__decap_4
XTAP_1394 VGND VPWR sky130_fd_sc_hd__tapvpwrvgnd_1
Xinput12 act_row0_in[5] VGND VGND VPWR VPWR net12 sky130_fd_sc_hd__clkbuf_4
XFILLER_0_37_593 VPWR VGND VPWR VGND sky130_ef_sc_hd__decap_12
Xinput45 psum_col0_in[1] VGND VGND VPWR VPWR net45 sky130_fd_sc_hd__buf_1
Xinput34 psum_col0_in[0] VGND VGND VPWR VPWR net34 sky130_fd_sc_hd__buf_1
XFILLER_0_108_993 VPWR VGND VPWR VGND sky130_ef_sc_hd__decap_12
Xinput23 act_row1_in[15] VGND VGND VPWR VPWR net23 sky130_fd_sc_hd__dlymetal6s2s_1
Xinput89 psum_col1_in[30] VGND VGND VPWR VPWR net89 sky130_fd_sc_hd__clkbuf_2
Xinput78 psum_col1_in[20] VGND VGND VPWR VPWR net78 sky130_fd_sc_hd__dlymetal6s2s_1
Xinput67 psum_col1_in[10] VGND VGND VPWR VPWR net67 sky130_fd_sc_hd__buf_1
Xinput56 psum_col0_in[2] VGND VGND VPWR VPWR net56 sky130_fd_sc_hd__buf_1
XFILLER_0_3_137 VPWR VGND VPWR VGND sky130_ef_sc_hd__decap_12
XFILLER_0_204_1337 VGND VGND VPWR VPWR sky130_fd_sc_hd__fill_1
XFILLER_0_110_613 VPWR VGND VPWR VGND sky130_ef_sc_hd__decap_12
XFILLER_0_110_657 VPWR VGND VPWR VGND sky130_ef_sc_hd__decap_12
XFILLER_0_97_1213 VPWR VGND VPWR VGND sky130_ef_sc_hd__decap_12
XFILLER_0_224_525 VGND VGND VPWR VPWR sky130_fd_sc_hd__decap_6
XFILLER_0_97_1279 VPWR VGND VPWR VGND sky130_ef_sc_hd__decap_12
XFILLER_0_224_569 VPWR VGND VPWR VGND sky130_ef_sc_hd__decap_12
XFILLER_0_137_1291 VPWR VGND VPWR VGND sky130_ef_sc_hd__decap_12
XFILLER_0_192_605 VPWR VGND VPWR VGND sky130_ef_sc_hd__decap_12
XFILLER_0_75_655 VGND VGND VPWR VPWR sky130_fd_sc_hd__fill_2
XFILLER_0_34_1263 VPWR VGND VPWR VGND sky130_ef_sc_hd__decap_12
XFILLER_0_7_421 VPWR VGND VPWR VGND sky130_ef_sc_hd__decap_12
XFILLER_0_28_593 VPWR VGND VPWR VGND sky130_ef_sc_hd__decap_12
XFILLER_0_209_1237 VPWR VGND VPWR VGND sky130_ef_sc_hd__decap_12
XFILLER_0_105_429 VPWR VGND VPWR VGND sky130_ef_sc_hd__decap_12
XFILLER_0_200_29 VPWR VGND VPWR VGND sky130_ef_sc_hd__decap_12
XFILLER_0_144_1251 VPWR VGND VPWR VGND sky130_ef_sc_hd__decap_12
XFILLER_0_105_1213 VPWR VGND VPWR VGND sky130_ef_sc_hd__decap_12
XFILLER_0_3_671 VGND VGND VPWR VPWR sky130_fd_sc_hd__fill_1
XFILLER_0_113_473 VPWR VGND VPWR VGND sky130_ef_sc_hd__decap_12
XFILLER_0_179_1303 VGND VGND VPWR VPWR sky130_fd_sc_hd__decap_6
XFILLER_0_144_1295 VPWR VGND VPWR VGND sky130_ef_sc_hd__decap_12
XFILLER_0_41_1201 VPWR VGND VPWR VGND sky130_ef_sc_hd__decap_12
XFILLER_0_209_27 VPWR VGND VPWR VGND sky130_ef_sc_hd__decap_12
XFILLER_0_105_1257 VPWR VGND VPWR VGND sky130_ef_sc_hd__decap_12
XFILLER_0_80_1283 VPWR VGND VPWR VGND sky130_ef_sc_hd__decap_12
XFILLER_0_220_1161 VPWR VGND VPWR VGND sky130_ef_sc_hd__decap_12
XFILLER_0_215_503 VGND VGND VPWR VPWR sky130_fd_sc_hd__fill_1
XFILLER_0_41_1267 VPWR VGND VPWR VGND sky130_ef_sc_hd__decap_12
XFILLER_0_76_1319 VPWR VGND VPWR VGND sky130_ef_sc_hd__decap_12
XFILLER_0_211_753 VPWR VGND VPWR VGND sky130_ef_sc_hd__decap_12
XFILLER_0_116_1331 VGND VGND VPWR VPWR sky130_fd_sc_hd__decap_6
XFILLER_0_183_605 VPWR VGND VPWR VGND sky130_ef_sc_hd__decap_12
XFILLER_0_151_1255 VPWR VGND VPWR VGND sky130_ef_sc_hd__decap_12
XFILLER_0_112_1217 VPWR VGND VPWR VGND sky130_ef_sc_hd__decap_12
XPHY_400 VGND VGND VPWR VPWR sky130_fd_sc_hd__decap_3
XANTENNA_input101_A w00[0] VGND VGND VPWR VPWR sky130_fd_sc_hd__diode_2
XFILLER_0_186_1307 VPWR VGND VPWR VGND sky130_ef_sc_hd__decap_12
XFILLER_0_211_797 VPWR VGND VPWR VGND sky130_ef_sc_hd__decap_12
XFILLER_0_66_655 VGND VGND VPWR VPWR sky130_fd_sc_hd__decap_4
XPHY_444 VGND VGND VPWR VPWR sky130_fd_sc_hd__decap_3
XPHY_433 VGND VGND VPWR VPWR sky130_fd_sc_hd__decap_3
XFILLER_0_13_1303 VGND VGND VPWR VPWR sky130_fd_sc_hd__decap_6
XPHY_411 VGND VGND VPWR VPWR sky130_fd_sc_hd__decap_3
XPHY_422 VGND VGND VPWR VPWR sky130_fd_sc_hd__decap_3
XPHY_1032 VGND VGND VPWR VPWR sky130_fd_sc_hd__decap_3
XPHY_1021 VGND VGND VPWR VPWR sky130_fd_sc_hd__decap_3
XPHY_1010 VGND VGND VPWR VPWR sky130_fd_sc_hd__decap_3
XPHY_455 VGND VGND VPWR VPWR sky130_fd_sc_hd__decap_3
XPHY_466 VGND VGND VPWR VPWR sky130_fd_sc_hd__decap_3
XFILLER_0_4_1161 VPWR VGND VPWR VGND sky130_ef_sc_hd__decap_12
XPHY_477 VGND VGND VPWR VPWR sky130_fd_sc_hd__decap_3
XPHY_1054 VGND VGND VPWR VPWR sky130_fd_sc_hd__decap_3
XPHY_1043 VGND VGND VPWR VPWR sky130_fd_sc_hd__decap_3
XPHY_1065 VGND VGND VPWR VPWR sky130_fd_sc_hd__decap_3
XFILLER_0_19_593 VPWR VGND VPWR VGND sky130_ef_sc_hd__decap_12
XFILLER_0_81_647 VPWR VGND VPWR VGND sky130_ef_sc_hd__decap_12
XPHY_488 VGND VGND VPWR VPWR sky130_fd_sc_hd__decap_3
XFILLER_0_108_245 VGND VGND VPWR VPWR sky130_fd_sc_hd__decap_6
XPHY_499 VGND VGND VPWR VPWR sky130_fd_sc_hd__decap_3
XPHY_1098 VGND VGND VPWR VPWR sky130_fd_sc_hd__decap_3
XPHY_1087 VGND VGND VPWR VPWR sky130_fd_sc_hd__decap_3
XPHY_1076 VGND VGND VPWR VPWR sky130_fd_sc_hd__decap_3
XFILLER_0_108_289 VPWR VGND VPWR VGND sky130_ef_sc_hd__decap_12
XFILLER_0_110_29 VPWR VGND VPWR VGND sky130_ef_sc_hd__decap_12
XFILLER_0_104_473 VGND VGND VPWR VPWR sky130_fd_sc_hd__decap_3
XFILLER_0_123_1335 VGND VGND VPWR VPWR sky130_fd_sc_hd__decap_8
XFILLER_0_219_853 VPWR VGND VPWR VGND sky130_ef_sc_hd__decap_12
XFILLER_0_192_9 VGND VGND VPWR VPWR sky130_fd_sc_hd__fill_2
XFILLER_0_218_363 VGND VGND VPWR VPWR sky130_fd_sc_hd__fill_1
XFILLER_0_28_25 VGND VGND VPWR VPWR sky130_fd_sc_hd__decap_3
XFILLER_0_20_1307 VPWR VGND VPWR VGND sky130_ef_sc_hd__decap_12
XFILLER_0_219_897 VPWR VGND VPWR VGND sky130_ef_sc_hd__decap_12
XFILLER_0_221_517 VPWR VGND VPWR VGND sky130_ef_sc_hd__decap_12
XFILLER_0_135_15 VPWR VGND VPWR VGND sky130_ef_sc_hd__decap_12
XFILLER_0_18_1225 VGND VGND VPWR VPWR sky130_fd_sc_hd__fill_1
XFILLER_0_215_81 VPWR VGND VPWR VGND sky130_ef_sc_hd__decap_12
XFILLER_0_130_1339 VGND VGND VPWR VPWR sky130_fd_sc_hd__decap_4
XFILLER_0_174_605 VPWR VGND VPWR VGND sky130_ef_sc_hd__decap_12
XFILLER_0_57_655 VGND VGND VPWR VPWR sky130_fd_sc_hd__fill_2
XFILLER_0_210_1341 VGND VGND VPWR VPWR sky130_fd_sc_hd__decap_3
XFILLER_0_151_47 VGND VGND VPWR VPWR sky130_fd_sc_hd__decap_3
XFILLER_0_219_3 VPWR VGND VPWR VGND sky130_ef_sc_hd__decap_12
XFILLER_0_121_3 VPWR VGND VPWR VGND sky130_ef_sc_hd__decap_12
XFILLER_0_128_1213 VPWR VGND VPWR VGND sky130_ef_sc_hd__decap_12
XFILLER_0_4_413 VGND VGND VPWR VPWR sky130_fd_sc_hd__decap_6
XFILLER_0_4_457 VPWR VGND VPWR VGND sky130_ef_sc_hd__decap_12
XFILLER_0_64_1201 VPWR VGND VPWR VGND sky130_ef_sc_hd__decap_12
XFILLER_0_114_237 VPWR VGND VPWR VGND sky130_ef_sc_hd__decap_12
XFILLER_0_208_1281 VGND VGND VPWR VPWR sky130_fd_sc_hd__fill_1
XFILLER_0_111_933 VPWR VGND VPWR VGND sky130_ef_sc_hd__decap_12
XFILLER_0_110_421 VPWR VGND VPWR VGND sky130_ef_sc_hd__decap_12
XFILLER_0_111_977 VPWR VGND VPWR VGND sky130_ef_sc_hd__decap_12
XFILLER_0_224_333 VPWR VGND VPWR VGND sky130_ef_sc_hd__decap_12
XFILLER_0_109_93 VPWR VGND VPWR VGND sky130_ef_sc_hd__decap_12
XFILLER_0_225_889 VGND VGND VPWR VPWR sky130_fd_sc_hd__decap_6
XFILLER_0_224_377 VPWR VGND VPWR VGND sky130_ef_sc_hd__decap_12
XTAP_2809 VGND VPWR sky130_fd_sc_hd__tapvpwrvgnd_1
XFILLER_0_26_3 VPWR VGND VPWR VGND sky130_ef_sc_hd__decap_12
XANTENNA_u_pe11_act_in[3] act_10_out_11_in\[3\] VGND VGND VPWR VPWR sky130_fd_sc_hd__diode_2
XFILLER_0_71_1249 VGND VGND VPWR VPWR sky130_fd_sc_hd__decap_4
XFILLER_0_165_605 VPWR VGND VPWR VGND sky130_ef_sc_hd__decap_12
XFILLER_0_48_655 VGND VGND VPWR VPWR sky130_fd_sc_hd__decap_4
XFILLER_0_1_1301 VPWR VGND VPWR VGND sky130_ef_sc_hd__decap_12
XFILLER_0_180_619 VPWR VGND VPWR VGND sky130_ef_sc_hd__decap_12
XFILLER_0_63_647 VGND VGND VPWR VPWR sky130_fd_sc_hd__decap_8
XFILLER_0_211_39 VPWR VGND VPWR VGND sky130_ef_sc_hd__decap_12
XFILLER_0_106_749 VGND VGND VPWR VPWR sky130_fd_sc_hd__decap_6
XFILLER_0_181_1237 VPWR VGND VPWR VGND sky130_ef_sc_hd__decap_12
XFILLER_0_105_237 VPWR VGND VPWR VGND sky130_ef_sc_hd__decap_12
XFILLER_0_219_105 VGND VGND VPWR VPWR sky130_fd_sc_hd__decap_6
XFILLER_0_105_1021 VPWR VGND VPWR VGND sky130_ef_sc_hd__decap_12
XFILLER_0_113_281 VPWR VGND VPWR VGND sky130_ef_sc_hd__decap_12
XFILLER_0_105_1065 VPWR VGND VPWR VGND sky130_ef_sc_hd__decap_12
XFILLER_0_219_149 VPWR VGND VPWR VGND sky130_ef_sc_hd__decap_12
XANTENNA_input149_A w11[0] VGND VGND VPWR VPWR sky130_fd_sc_hd__diode_2
XFILLER_0_216_867 VGND VGND VPWR VPWR sky130_fd_sc_hd__fill_1
XFILLER_0_216_1005 VPWR VGND VPWR VGND sky130_ef_sc_hd__decap_12
XFILLER_0_216_1049 VPWR VGND VPWR VGND sky130_ef_sc_hd__decap_12
XFILLER_0_211_561 VPWR VGND VPWR VGND sky130_ef_sc_hd__decap_12
XFILLER_0_156_605 VPWR VGND VPWR VGND sky130_ef_sc_hd__decap_12
XFILLER_0_14_49 VGND VGND VPWR VPWR sky130_fd_sc_hd__fill_1
XFILLER_0_39_655 VGND VGND VPWR VPWR sky130_fd_sc_hd__fill_2
XPHY_241 VGND VGND VPWR VPWR sky130_fd_sc_hd__decap_3
XPHY_252 VGND VGND VPWR VPWR sky130_fd_sc_hd__decap_3
XFILLER_0_17_1291 VPWR VGND VPWR VGND sky130_ef_sc_hd__decap_12
XPHY_230 VGND VGND VPWR VPWR sky130_fd_sc_hd__decap_3
XPHY_274 VGND VGND VPWR VPWR sky130_fd_sc_hd__decap_3
XPHY_263 VGND VGND VPWR VPWR sky130_fd_sc_hd__decap_3
XPHY_285 VGND VGND VPWR VPWR sky130_fd_sc_hd__decap_3
XFILLER_0_87_1201 VPWR VGND VPWR VGND sky130_ef_sc_hd__decap_12
XFILLER_0_30_15 VPWR VGND VPWR VGND sky130_ef_sc_hd__decap_12
XPHY_296 VGND VGND VPWR VPWR sky130_fd_sc_hd__decap_3
XFILLER_0_87_1267 VPWR VGND VPWR VGND sky130_ef_sc_hd__decap_12
XFILLER_0_121_39 VGND VGND VPWR VPWR sky130_fd_sc_hd__decap_8
XFILLER_0_223_1009 VPWR VGND VPWR VGND sky130_ef_sc_hd__decap_12
XFILLER_0_2_917 VGND VGND VPWR VPWR sky130_fd_sc_hd__decap_6
XFILLER_0_1_405 VPWR VGND VPWR VGND sky130_ef_sc_hd__decap_12
XFILLER_0_1_449 VPWR VGND VPWR VGND sky130_ef_sc_hd__decap_12
XFILLER_0_104_281 VPWR VGND VPWR VGND sky130_ef_sc_hd__decap_12
XFILLER_0_24_1251 VPWR VGND VPWR VGND sky130_ef_sc_hd__decap_12
XFILLER_0_197_1255 VPWR VGND VPWR VGND sky130_ef_sc_hd__decap_12
XFILLER_0_24_1295 VPWR VGND VPWR VGND sky130_ef_sc_hd__decap_12
XFILLER_0_59_1303 VGND VGND VPWR VPWR sky130_fd_sc_hd__decap_6
XFILLER_0_158_1239 VPWR VGND VPWR VGND sky130_ef_sc_hd__decap_12
XFILLER_0_94_1227 VPWR VGND VPWR VGND sky130_ef_sc_hd__decap_12
XFILLER_0_222_837 VPWR VGND VPWR VGND sky130_ef_sc_hd__decap_12
XFILLER_0_169_3 VPWR VGND VPWR VGND sky130_ef_sc_hd__decap_12
XFILLER_0_7_1009 VPWR VGND VPWR VGND sky130_ef_sc_hd__decap_12
XFILLER_0_134_1283 VPWR VGND VPWR VGND sky130_ef_sc_hd__decap_12
XFILLER_0_147_605 VPWR VGND VPWR VGND sky130_ef_sc_hd__decap_12
XFILLER_0_169_1335 VGND VGND VPWR VPWR sky130_fd_sc_hd__decap_8
XFILLER_0_162_619 VPWR VGND VPWR VGND sky130_ef_sc_hd__decap_12
XFILLER_0_45_647 VGND VGND VPWR VPWR sky130_fd_sc_hd__decap_8
XFILLER_0_31_1255 VPWR VGND VPWR VGND sky130_ef_sc_hd__decap_12
XFILLER_0_66_1307 VPWR VGND VPWR VGND sky130_ef_sc_hd__decap_12
XFILLER_0_4_221 VPWR VGND VPWR VGND sky130_ef_sc_hd__decap_12
XFILLER_0_60_617 VGND VGND VPWR VPWR sky130_fd_sc_hd__fill_1
XFILLER_0_4_265 VPWR VGND VPWR VGND sky130_ef_sc_hd__decap_12
XFILLER_0_5_777 VGND VGND VPWR VPWR sky130_fd_sc_hd__decap_6
XFILLER_0_180_1281 VGND VGND VPWR VPWR sky130_fd_sc_hd__fill_1
XFILLER_0_106_1341 VGND VGND VPWR VPWR sky130_fd_sc_hd__decap_3
XFILLER_0_111_741 VPWR VGND VPWR VGND sky130_ef_sc_hd__decap_12
XFILLER_0_96_41 VGND VGND VPWR VPWR sky130_fd_sc_hd__decap_8
XFILLER_0_217_609 VGND VGND VPWR VPWR sky130_fd_sc_hd__decap_6
XFILLER_0_102_1227 VPWR VGND VPWR VGND sky130_ef_sc_hd__decap_12
XFILLER_0_111_785 VPWR VGND VPWR VGND sky130_ef_sc_hd__decap_12
XFILLER_0_0_471 VGND VGND VPWR VPWR sky130_fd_sc_hd__decap_4
XFILLER_0_110_251 VGND VGND VPWR VPWR sky130_fd_sc_hd__fill_1
XFILLER_0_0_493 VGND VGND VPWR VPWR sky130_fd_sc_hd__decap_8
XFILLER_0_176_1339 VGND VGND VPWR VPWR sky130_fd_sc_hd__decap_4
XFILLER_0_225_653 VPWR VGND VPWR VGND sky130_ef_sc_hd__decap_12
XFILLER_0_217_1325 VPWR VGND VPWR VGND sky130_ef_sc_hd__decap_12
XFILLER_0_224_141 VPWR VGND VPWR VGND sky130_ef_sc_hd__decap_12
XFILLER_0_225_697 VPWR VGND VPWR VGND sky130_ef_sc_hd__decap_12
XTAP_2606 VGND VPWR sky130_fd_sc_hd__tapvpwrvgnd_1
XTAP_2617 VGND VPWR sky130_fd_sc_hd__tapvpwrvgnd_1
XTAP_2628 VGND VPWR sky130_fd_sc_hd__tapvpwrvgnd_1
XTAP_2639 VGND VPWR sky130_fd_sc_hd__tapvpwrvgnd_1
XTAP_1905 VGND VPWR sky130_fd_sc_hd__tapvpwrvgnd_1
XTAP_1916 VGND VPWR sky130_fd_sc_hd__tapvpwrvgnd_1
XFILLER_0_113_1301 VPWR VGND VPWR VGND sky130_ef_sc_hd__decap_12
XTAP_1949 VGND VPWR sky130_fd_sc_hd__tapvpwrvgnd_1
XTAP_1927 VGND VPWR sky130_fd_sc_hd__tapvpwrvgnd_1
XFILLER_0_138_605 VPWR VGND VPWR VGND sky130_ef_sc_hd__decap_12
XTAP_1938 VGND VPWR sky130_fd_sc_hd__tapvpwrvgnd_1
XFILLER_0_222_27 VGND VGND VPWR VPWR sky130_fd_sc_hd__fill_1
XFILLER_0_106_513 VPWR VGND VPWR VGND sky130_ef_sc_hd__decap_12
XFILLER_0_10_1339 VGND VGND VPWR VPWR sky130_fd_sc_hd__decap_3
XFILLER_0_161_641 VGND VGND VPWR VPWR sky130_fd_sc_hd__decap_4
XFILLER_0_106_557 VPWR VGND VPWR VGND sky130_ef_sc_hd__decap_12
XFILLER_0_8_593 VPWR VGND VPWR VGND sky130_ef_sc_hd__decap_12
XFILLER_0_51_617 VPWR VGND VPWR VGND sky130_ef_sc_hd__decap_12
XFILLER_0_1_1175 VGND VGND VPWR VPWR sky130_fd_sc_hd__fill_1
XFILLER_0_224_1329 VPWR VGND VPWR VGND sky130_ef_sc_hd__decap_12
XANTENNA_u_pe10_weight_in[12] net136 VGND VGND VPWR VPWR sky130_fd_sc_hd__diode_2
XFILLER_0_118_1201 VPWR VGND VPWR VGND sky130_ef_sc_hd__decap_12
XFILLER_0_25_15 VPWR VGND VPWR VGND sky130_ef_sc_hd__decap_12
XFILLER_0_8_1307 VPWR VGND VPWR VGND sky130_ef_sc_hd__decap_12
XFILLER_0_212_881 VPWR VGND VPWR VGND sky130_ef_sc_hd__decap_12
XFILLER_0_129_605 VPWR VGND VPWR VGND sky130_ef_sc_hd__decap_12
XFILLER_0_196_593 VPWR VGND VPWR VGND sky130_ef_sc_hd__decap_12
XFILLER_0_211_391 VGND VGND VPWR VPWR sky130_fd_sc_hd__fill_1
XFILLER_0_132_27 VGND VGND VPWR VPWR sky130_fd_sc_hd__fill_1
XFILLER_0_144_619 VPWR VGND VPWR VGND sky130_ef_sc_hd__decap_12
XFILLER_0_41_47 VGND VGND VPWR VPWR sky130_fd_sc_hd__fill_1
XFILLER_0_132_49 VGND VGND VPWR VPWR sky130_fd_sc_hd__fill_1
XFILLER_0_27_647 VGND VGND VPWR VPWR sky130_fd_sc_hd__decap_8
XFILLER_0_109_373 VPWR VGND VPWR VGND sky130_ef_sc_hd__decap_12
XFILLER_0_42_617 VGND VGND VPWR VPWR sky130_fd_sc_hd__fill_1
XANTENNA_u_pe01_act_in[6] act_00_out_01_in\[6\] VGND VGND VPWR VPWR sky130_fd_sc_hd__diode_2
XFILLER_0_2_725 VPWR VGND VPWR VGND sky130_ef_sc_hd__decap_12
XFILLER_0_125_1249 VGND VGND VPWR VPWR sky130_fd_sc_hd__decap_4
XFILLER_0_2_769 VPWR VGND VPWR VGND sky130_ef_sc_hd__decap_12
XFILLER_0_61_1237 VPWR VGND VPWR VGND sky130_ef_sc_hd__decap_12
XFILLER_0_1_279 VGND VGND VPWR VPWR sky130_fd_sc_hd__fill_1
XFILLER_0_226_428 VPWR VGND VPWR VGND sky130_ef_sc_hd__decap_12
XFILLER_0_120_593 VPWR VGND VPWR VGND sky130_ef_sc_hd__decap_12
XFILLER_0_66_22 VGND VGND VPWR VPWR sky130_fd_sc_hd__decap_6
XFILLER_0_5_69 VPWR VGND VPWR VGND sky130_ef_sc_hd__decap_12
XFILLER_0_157_46 VGND VGND VPWR VPWR sky130_fd_sc_hd__decap_4
XFILLER_0_222_601 VPWR VGND VPWR VGND sky130_ef_sc_hd__decap_12
XFILLER_0_222_645 VPWR VGND VPWR VGND sky130_ef_sc_hd__decap_12
XFILLER_0_221_111 VGND VGND VPWR VPWR sky130_fd_sc_hd__fill_1
XFILLER_0_171_1225 VPWR VGND VPWR VGND sky130_ef_sc_hd__decap_12
XFILLER_0_187_593 VPWR VGND VPWR VGND sky130_ef_sc_hd__decap_12
XFILLER_0_106_83 VGND VGND VPWR VPWR sky130_fd_sc_hd__fill_1
XFILLER_0_143_641 VGND VGND VPWR VPWR sky130_fd_sc_hd__decap_4
XFILLER_0_5_541 VPWR VGND VPWR VGND sky130_ef_sc_hd__decap_12
XFILLER_0_33_617 VPWR VGND VPWR VGND sky130_ef_sc_hd__decap_12
XFILLER_0_93_3 VPWR VGND VPWR VGND sky130_ef_sc_hd__decap_12
XFILLER_0_182_1343 VGND VGND VPWR VPWR sky130_fd_sc_hd__fill_1
XFILLER_0_5_585 VPWR VGND VPWR VGND sky130_ef_sc_hd__decap_12
XFILLER_0_1_9 VGND VGND VPWR VPWR sky130_fd_sc_hd__fill_2
XFILLER_0_217_417 VPWR VGND VPWR VGND sky130_ef_sc_hd__decap_12
XFILLER_0_225_461 VPWR VGND VPWR VGND sky130_ef_sc_hd__decap_12
XFILLER_0_217_49 VGND VGND VPWR VPWR sky130_fd_sc_hd__decap_6
XFILLER_0_217_1133 VPWR VGND VPWR VGND sky130_ef_sc_hd__decap_12
XFILLER_0_38_1239 VPWR VGND VPWR VGND sky130_ef_sc_hd__decap_12
XFILLER_0_77_1255 VPWR VGND VPWR VGND sky130_ef_sc_hd__decap_12
XFILLER_0_217_1177 VPWR VGND VPWR VGND sky130_ef_sc_hd__decap_12
XTAP_2436 VGND VPWR sky130_fd_sc_hd__tapvpwrvgnd_1
XTAP_2403 VGND VPWR sky130_fd_sc_hd__tapvpwrvgnd_1
XTAP_2414 VGND VPWR sky130_fd_sc_hd__tapvpwrvgnd_1
XFILLER_0_212_133 VGND VGND VPWR VPWR sky130_fd_sc_hd__decap_6
XTAP_2425 VGND VPWR sky130_fd_sc_hd__tapvpwrvgnd_1
XTAP_2469 VGND VPWR sky130_fd_sc_hd__tapvpwrvgnd_1
XTAP_2447 VGND VPWR sky130_fd_sc_hd__tapvpwrvgnd_1
XTAP_2458 VGND VPWR sky130_fd_sc_hd__tapvpwrvgnd_1
XFILLER_0_212_177 VPWR VGND VPWR VGND sky130_ef_sc_hd__decap_12
XTAP_1702 VGND VPWR sky130_fd_sc_hd__tapvpwrvgnd_1
XTAP_1713 VGND VPWR sky130_fd_sc_hd__tapvpwrvgnd_1
XTAP_1724 VGND VPWR sky130_fd_sc_hd__tapvpwrvgnd_1
XFILLER_0_178_593 VPWR VGND VPWR VGND sky130_ef_sc_hd__decap_12
XTAP_1757 VGND VPWR sky130_fd_sc_hd__tapvpwrvgnd_1
XTAP_1746 VGND VPWR sky130_fd_sc_hd__tapvpwrvgnd_1
XTAP_1735 VGND VPWR sky130_fd_sc_hd__tapvpwrvgnd_1
XFILLER_0_113_1175 VGND VGND VPWR VPWR sky130_fd_sc_hd__fill_1
XTAP_1779 VGND VPWR sky130_fd_sc_hd__tapvpwrvgnd_1
XTAP_1768 VGND VPWR sky130_fd_sc_hd__tapvpwrvgnd_1
XFILLER_0_126_619 VPWR VGND VPWR VGND sky130_ef_sc_hd__decap_12
XFILLER_0_14_1283 VPWR VGND VPWR VGND sky130_ef_sc_hd__decap_12
XFILLER_0_148_1227 VPWR VGND VPWR VGND sky130_ef_sc_hd__decap_12
XFILLER_0_107_833 VGND VGND VPWR VPWR sky130_fd_sc_hd__decap_6
XFILLER_0_11_39 VGND VGND VPWR VPWR sky130_fd_sc_hd__decap_8
XFILLER_0_24_617 VGND VGND VPWR VPWR sky130_fd_sc_hd__fill_1
XFILLER_0_106_321 VPWR VGND VPWR VGND sky130_ef_sc_hd__decap_12
XFILLER_0_107_877 VPWR VGND VPWR VGND sky130_ef_sc_hd__decap_12
XFILLER_0_49_1335 VGND VGND VPWR VPWR sky130_fd_sc_hd__decap_8
XFILLER_0_106_365 VPWR VGND VPWR VGND sky130_ef_sc_hd__decap_12
XANTENNA_input77_A psum_col1_in[1] VGND VGND VPWR VPWR sky130_fd_sc_hd__diode_2
XFILLER_0_102_593 VPWR VGND VPWR VGND sky130_ef_sc_hd__decap_12
XFILLER_0_194_1225 VGND VGND VPWR VPWR sky130_fd_sc_hd__fill_1
XFILLER_0_217_951 VGND VGND VPWR VPWR sky130_fd_sc_hd__fill_1
XFILLER_0_159_1323 VPWR VGND VPWR VGND sky130_ef_sc_hd__decap_12
XFILLER_0_60_1281 VGND VGND VPWR VPWR sky130_fd_sc_hd__fill_1
XFILLER_0_95_1311 VPWR VGND VPWR VGND sky130_ef_sc_hd__decap_12
XFILLER_0_127_27 VPWR VGND VPWR VGND sky130_ef_sc_hd__decap_12
XFILLER_0_56_1339 VGND VGND VPWR VPWR sky130_fd_sc_hd__decap_4
XFILLER_0_52_13 VPWR VGND VPWR VGND sky130_ef_sc_hd__decap_12
XFILLER_0_169_593 VPWR VGND VPWR VGND sky130_ef_sc_hd__decap_12
XFILLER_0_131_1253 VGND VGND VPWR VPWR sky130_fd_sc_hd__fill_1
XFILLER_0_223_81 VPWR VGND VPWR VGND sky130_ef_sc_hd__decap_12
XFILLER_0_125_641 VGND VGND VPWR VPWR sky130_fd_sc_hd__decap_4
XFILLER_0_15_617 VPWR VGND VPWR VGND sky130_ef_sc_hd__decap_12
XFILLER_0_109_181 VPWR VGND VPWR VGND sky130_ef_sc_hd__decap_12
XFILLER_0_201_3 VPWR VGND VPWR VGND sky130_ef_sc_hd__decap_12
XFILLER_0_207_1335 VGND VGND VPWR VPWR sky130_fd_sc_hd__decap_8
XFILLER_0_2_533 VPWR VGND VPWR VGND sky130_ef_sc_hd__decap_12
XFILLER_0_140_655 VGND VGND VPWR VPWR sky130_fd_sc_hd__decap_4
XFILLER_0_77_10 VPWR VGND VPWR VGND sky130_ef_sc_hd__decap_12
XFILLER_0_112_357 VGND VGND VPWR VPWR sky130_fd_sc_hd__decap_6
XFILLER_0_103_1311 VPWR VGND VPWR VGND sky130_ef_sc_hd__decap_12
XFILLER_0_173_1309 VGND VGND VPWR VPWR sky130_fd_sc_hd__fill_1
XFILLER_0_223_921 VPWR VGND VPWR VGND sky130_ef_sc_hd__decap_12
XFILLER_0_214_1317 VPWR VGND VPWR VGND sky130_ef_sc_hd__decap_12
XFILLER_0_223_965 VPWR VGND VPWR VGND sky130_ef_sc_hd__decap_12
XFILLER_0_222_475 VGND VGND VPWR VPWR sky130_fd_sc_hd__fill_1
XPHY_818 VGND VGND VPWR VPWR sky130_fd_sc_hd__decap_3
XPHY_807 VGND VGND VPWR VPWR sky130_fd_sc_hd__decap_3
XPHY_829 VGND VGND VPWR VPWR sky130_fd_sc_hd__decap_3
XFILLER_0_212_1085 VGND VGND VPWR VPWR sky130_fd_sc_hd__decap_6
XFILLER_0_110_1315 VGND VGND VPWR VPWR sky130_fd_sc_hd__fill_1
XFILLER_0_6_861 VGND VGND VPWR VPWR sky130_fd_sc_hd__decap_6
XFILLER_0_104_825 VPWR VGND VPWR VGND sky130_ef_sc_hd__decap_12
XFILLER_0_131_655 VGND VGND VPWR VPWR sky130_fd_sc_hd__fill_2
XFILLER_0_104_869 VPWR VGND VPWR VGND sky130_ef_sc_hd__decap_12
XFILLER_0_5_393 VPWR VGND VPWR VGND sky130_ef_sc_hd__decap_12
XFILLER_0_218_737 VPWR VGND VPWR VGND sky130_ef_sc_hd__decap_12
XFILLER_0_217_225 VPWR VGND VPWR VGND sky130_ef_sc_hd__decap_12
XANTENNA_input131_A w01[8] VGND VGND VPWR VPWR sky130_fd_sc_hd__diode_2
XFILLER_0_193_1291 VPWR VGND VPWR VGND sky130_ef_sc_hd__decap_12
XFILLER_0_198_655 VGND VGND VPWR VPWR sky130_fd_sc_hd__decap_4
XTAP_2200 VGND VPWR sky130_fd_sc_hd__tapvpwrvgnd_1
XFILLER_0_154_1275 VGND VGND VPWR VPWR sky130_fd_sc_hd__decap_6
XTAP_2244 VGND VPWR sky130_fd_sc_hd__tapvpwrvgnd_1
XTAP_2211 VGND VPWR sky130_fd_sc_hd__tapvpwrvgnd_1
XTAP_2222 VGND VPWR sky130_fd_sc_hd__tapvpwrvgnd_1
XFILLER_0_96_631 VPWR VGND VPWR VGND sky130_ef_sc_hd__decap_12
XTAP_2233 VGND VPWR sky130_fd_sc_hd__tapvpwrvgnd_1
XFILLER_0_213_497 VGND VGND VPWR VPWR sky130_fd_sc_hd__decap_6
XTAP_2277 VGND VPWR sky130_fd_sc_hd__tapvpwrvgnd_1
XTAP_2255 VGND VPWR sky130_fd_sc_hd__tapvpwrvgnd_1
XFILLER_0_115_1237 VPWR VGND VPWR VGND sky130_ef_sc_hd__decap_12
XFILLER_0_90_1263 VPWR VGND VPWR VGND sky130_ef_sc_hd__decap_12
XTAP_2266 VGND VPWR sky130_fd_sc_hd__tapvpwrvgnd_1
XTAP_1510 VGND VPWR sky130_fd_sc_hd__tapvpwrvgnd_1
XTAP_1521 VGND VPWR sky130_fd_sc_hd__tapvpwrvgnd_1
XTAP_1532 VGND VPWR sky130_fd_sc_hd__tapvpwrvgnd_1
XFILLER_0_51_1225 VPWR VGND VPWR VGND sky130_ef_sc_hd__decap_12
XTAP_2299 VGND VPWR sky130_fd_sc_hd__tapvpwrvgnd_1
XTAP_2288 VGND VPWR sky130_fd_sc_hd__tapvpwrvgnd_1
XTAP_1565 VGND VPWR sky130_fd_sc_hd__tapvpwrvgnd_1
XPHY_83 VGND VGND VPWR VPWR sky130_fd_sc_hd__decap_3
XPHY_61 VGND VGND VPWR VPWR sky130_fd_sc_hd__decap_3
XPHY_72 VGND VGND VPWR VPWR sky130_fd_sc_hd__decap_3
XTAP_1554 VGND VPWR sky130_fd_sc_hd__tapvpwrvgnd_1
XFILLER_0_3_1001 VGND VGND VPWR VPWR sky130_fd_sc_hd__decap_6
XPHY_50 VGND VGND VPWR VPWR sky130_fd_sc_hd__decap_3
XTAP_1543 VGND VPWR sky130_fd_sc_hd__tapvpwrvgnd_1
XTAP_1576 VGND VPWR sky130_fd_sc_hd__tapvpwrvgnd_1
XFILLER_0_22_49 VGND VGND VPWR VPWR sky130_fd_sc_hd__fill_1
XFILLER_0_22_27 VGND VGND VPWR VPWR sky130_fd_sc_hd__fill_1
XPHY_94 VGND VGND VPWR VPWR sky130_fd_sc_hd__decap_3
XTAP_1598 VGND VPWR sky130_fd_sc_hd__tapvpwrvgnd_1
XFILLER_0_3_1045 VPWR VGND VPWR VGND sky130_ef_sc_hd__decap_12
XTAP_1587 VGND VPWR sky130_fd_sc_hd__tapvpwrvgnd_1
XFILLER_0_3_1089 VPWR VGND VPWR VGND sky130_ef_sc_hd__decap_12
XFILLER_0_107_641 VPWR VGND VPWR VGND sky130_ef_sc_hd__decap_12
XFILLER_0_107_685 VPWR VGND VPWR VGND sky130_ef_sc_hd__decap_12
XFILLER_0_161_1213 VPWR VGND VPWR VGND sky130_ef_sc_hd__decap_12
XFILLER_0_122_655 VGND VGND VPWR VPWR sky130_fd_sc_hd__decap_4
XFILLER_0_106_195 VGND VGND VPWR VPWR sky130_fd_sc_hd__fill_1
XFILLER_0_20_631 VPWR VGND VPWR VGND sky130_ef_sc_hd__decap_12
XFILLER_0_62_1343 VGND VGND VPWR VPWR sky130_fd_sc_hd__fill_1
XFILLER_0_161_1279 VPWR VGND VPWR VGND sky130_ef_sc_hd__decap_12
XFILLER_0_138_15 VPWR VGND VPWR VGND sky130_ef_sc_hd__decap_12
XFILLER_0_223_217 VGND VGND VPWR VPWR sky130_fd_sc_hd__decap_6
XFILLER_0_2_15 VPWR VGND VPWR VGND sky130_ef_sc_hd__decap_12
XFILLER_0_172_1331 VGND VGND VPWR VPWR sky130_fd_sc_hd__decap_6
XFILLER_0_63_34 VPWR VGND VPWR VGND sky130_ef_sc_hd__decap_12
XFILLER_0_151_3 VPWR VGND VPWR VGND sky130_ef_sc_hd__decap_12
XFILLER_0_220_979 VGND VGND VPWR VPWR sky130_fd_sc_hd__fill_1
XFILLER_0_7_669 VGND VGND VPWR VPWR sky130_fd_sc_hd__decap_3
XFILLER_0_3_853 VPWR VGND VPWR VGND sky130_ef_sc_hd__decap_12
XFILLER_0_28_1227 VPWR VGND VPWR VGND sky130_ef_sc_hd__decap_12
XFILLER_0_112_121 VPWR VGND VPWR VGND sky130_ef_sc_hd__decap_12
XFILLER_0_140_1319 VPWR VGND VPWR VGND sky130_ef_sc_hd__decap_12
XFILLER_0_3_897 VPWR VGND VPWR VGND sky130_ef_sc_hd__decap_12
XFILLER_0_2_363 VGND VGND VPWR VPWR sky130_fd_sc_hd__fill_1
XFILLER_0_112_165 VPWR VGND VPWR VGND sky130_ef_sc_hd__decap_12
Xoutput166 net166 VGND VGND VPWR VPWR psum_col0_out[10] sky130_fd_sc_hd__clkbuf_4
Xoutput177 net177 VGND VGND VPWR VPWR psum_col0_out[20] sky130_fd_sc_hd__clkbuf_4
Xoutput199 net199 VGND VGND VPWR VPWR psum_col1_out[11] sky130_fd_sc_hd__clkbuf_4
Xoutput188 net188 VGND VGND VPWR VPWR psum_col0_out[30] sky130_fd_sc_hd__clkbuf_4
XFILLER_0_215_729 VPWR VGND VPWR VGND sky130_ef_sc_hd__decap_12
XFILLER_0_177_1253 VGND VGND VPWR VPWR sky130_fd_sc_hd__fill_1
XFILLER_0_39_1323 VPWR VGND VPWR VGND sky130_ef_sc_hd__decap_12
XFILLER_0_74_1225 VGND VGND VPWR VPWR sky130_fd_sc_hd__fill_1
XFILLER_0_218_1261 VPWR VGND VPWR VGND sky130_ef_sc_hd__decap_12
XFILLER_0_78_631 VPWR VGND VPWR VGND sky130_ef_sc_hd__decap_12
XFILLER_0_214_1147 VGND VGND VPWR VPWR sky130_fd_sc_hd__fill_1
XFILLER_0_195_647 VPWR VGND VPWR VGND sky130_ef_sc_hd__decap_12
XFILLER_0_210_445 VGND VGND VPWR VPWR sky130_fd_sc_hd__decap_3
XPHY_604 VGND VGND VPWR VPWR sky130_fd_sc_hd__decap_3
XPHY_615 VGND VGND VPWR VPWR sky130_fd_sc_hd__decap_3
XPHY_626 VGND VGND VPWR VPWR sky130_fd_sc_hd__decap_3
XPHY_1203 VGND VGND VPWR VPWR sky130_fd_sc_hd__decap_3
XPHY_1214 VGND VGND VPWR VPWR sky130_fd_sc_hd__decap_3
XPHY_648 VGND VGND VPWR VPWR sky130_fd_sc_hd__decap_3
XPHY_637 VGND VGND VPWR VPWR sky130_fd_sc_hd__decap_3
XPHY_659 VGND VGND VPWR VPWR sky130_fd_sc_hd__decap_3
XFILLER_0_93_645 VGND VGND VPWR VPWR sky130_fd_sc_hd__fill_1
XFILLER_0_184_1213 VPWR VGND VPWR VGND sky130_ef_sc_hd__decap_12
XFILLER_0_149_1311 VPWR VGND VPWR VGND sky130_ef_sc_hd__decap_12
XFILLER_0_11_1253 VGND VGND VPWR VPWR sky130_fd_sc_hd__fill_1
XFILLER_0_85_1343 VGND VGND VPWR VPWR sky130_fd_sc_hd__fill_1
XFILLER_0_225_1287 VGND VGND VPWR VPWR sky130_fd_sc_hd__fill_1
XFILLER_0_218_501 VPWR VGND VPWR VGND sky130_ef_sc_hd__decap_12
XFILLER_0_108_1085 VGND VGND VPWR VPWR sky130_fd_sc_hd__decap_6
XFILLER_0_218_545 VPWR VGND VPWR VGND sky130_ef_sc_hd__decap_12
XFILLER_0_218_589 VPWR VGND VPWR VGND sky130_ef_sc_hd__decap_12
XFILLER_0_108_29 VPWR VGND VPWR VGND sky130_ef_sc_hd__decap_12
XFILLER_0_156_1337 VGND VGND VPWR VPWR sky130_fd_sc_hd__fill_1
XFILLER_0_17_49 VGND VGND VPWR VPWR sky130_fd_sc_hd__fill_1
XFILLER_0_220_209 VPWR VGND VPWR VGND sky130_ef_sc_hd__decap_12
XFILLER_0_213_261 VPWR VGND VPWR VGND sky130_ef_sc_hd__decap_12
XFILLER_0_53_1309 VGND VGND VPWR VPWR sky130_fd_sc_hd__fill_1
XTAP_2041 VGND VPWR sky130_fd_sc_hd__tapvpwrvgnd_1
XFILLER_0_33_15 VPWR VGND VPWR VGND sky130_ef_sc_hd__decap_12
XTAP_2030 VGND VPWR sky130_fd_sc_hd__tapvpwrvgnd_1
XTAP_2052 VGND VPWR sky130_fd_sc_hd__tapvpwrvgnd_1
XTAP_2085 VGND VPWR sky130_fd_sc_hd__tapvpwrvgnd_1
XTAP_2063 VGND VPWR sky130_fd_sc_hd__tapvpwrvgnd_1
XTAP_1340 VGND VPWR sky130_fd_sc_hd__tapvpwrvgnd_1
XTAP_2074 VGND VPWR sky130_fd_sc_hd__tapvpwrvgnd_1
XTAP_1362 VGND VPWR sky130_fd_sc_hd__tapvpwrvgnd_1
XTAP_1384 VGND VPWR sky130_fd_sc_hd__tapvpwrvgnd_1
XTAP_1373 VGND VPWR sky130_fd_sc_hd__tapvpwrvgnd_1
XTAP_1351 VGND VPWR sky130_fd_sc_hd__tapvpwrvgnd_1
XTAP_2096 VGND VPWR sky130_fd_sc_hd__tapvpwrvgnd_1
XTAP_1395 VGND VPWR sky130_fd_sc_hd__tapvpwrvgnd_1
XFILLER_0_108_961 VPWR VGND VPWR VGND sky130_ef_sc_hd__decap_12
Xinput13 act_row0_in[6] VGND VGND VPWR VPWR net13 sky130_fd_sc_hd__clkbuf_4
XFILLER_0_140_49 VGND VGND VPWR VPWR sky130_fd_sc_hd__fill_1
XFILLER_0_226_1018 VPWR VGND VPWR VGND sky130_ef_sc_hd__decap_12
Xinput46 psum_col0_in[20] VGND VGND VPWR VPWR net46 sky130_fd_sc_hd__buf_1
Xinput35 psum_col0_in[10] VGND VGND VPWR VPWR net35 sky130_fd_sc_hd__buf_1
Xinput24 act_row1_in[1] VGND VGND VPWR VPWR net24 sky130_fd_sc_hd__buf_1
XFILLER_0_3_105 VGND VGND VPWR VPWR sky130_fd_sc_hd__decap_6
Xinput79 psum_col1_in[21] VGND VGND VPWR VPWR net79 sky130_fd_sc_hd__dlymetal6s2s_1
Xinput68 psum_col1_in[11] VGND VGND VPWR VPWR net68 sky130_fd_sc_hd__buf_1
Xinput57 psum_col0_in[30] VGND VGND VPWR VPWR net57 sky130_fd_sc_hd__buf_1
XFILLER_0_3_149 VPWR VGND VPWR VGND sky130_ef_sc_hd__decap_12
XFILLER_0_0_823 VPWR VGND VPWR VGND sky130_ef_sc_hd__decap_12
XFILLER_0_0_801 VGND VGND VPWR VPWR sky130_fd_sc_hd__decap_8
XFILLER_0_110_625 VPWR VGND VPWR VGND sky130_ef_sc_hd__decap_12
XFILLER_0_149_47 VGND VGND VPWR VPWR sky130_fd_sc_hd__decap_3
XFILLER_0_110_669 VPWR VGND VPWR VGND sky130_ef_sc_hd__decap_12
XFILLER_0_0_889 VGND VGND VPWR VPWR sky130_fd_sc_hd__decap_6
XFILLER_0_0_867 VGND VGND VPWR VPWR sky130_fd_sc_hd__fill_1
XFILLER_0_97_1225 VPWR VGND VPWR VGND sky130_ef_sc_hd__decap_12
XFILLER_0_42_9 VGND VGND VPWR VPWR sky130_fd_sc_hd__fill_2
XFILLER_0_177_647 VGND VGND VPWR VPWR sky130_fd_sc_hd__decap_8
XFILLER_0_73_1291 VPWR VGND VPWR VGND sky130_ef_sc_hd__decap_12
XFILLER_0_192_617 VGND VGND VPWR VPWR sky130_fd_sc_hd__fill_1
XFILLER_0_75_645 VGND VGND VPWR VPWR sky130_fd_sc_hd__fill_1
XFILLER_0_34_1275 VGND VGND VPWR VPWR sky130_fd_sc_hd__decap_6
XFILLER_0_7_433 VPWR VGND VPWR VGND sky130_ef_sc_hd__decap_12
XFILLER_0_209_1249 VGND VGND VPWR VPWR sky130_fd_sc_hd__decap_4
XFILLER_0_7_477 VPWR VGND VPWR VGND sky130_ef_sc_hd__decap_12
XFILLER_0_114_953 VPWR VGND VPWR VGND sky130_ef_sc_hd__decap_12
XFILLER_0_113_441 VGND VGND VPWR VPWR sky130_fd_sc_hd__decap_6
XFILLER_0_144_1263 VPWR VGND VPWR VGND sky130_ef_sc_hd__decap_12
XFILLER_0_105_1225 VGND VGND VPWR VPWR sky130_fd_sc_hd__decap_6
XFILLER_0_101_647 VPWR VGND VPWR VGND sky130_ef_sc_hd__decap_12
XFILLER_0_80_1251 VPWR VGND VPWR VGND sky130_ef_sc_hd__decap_12
XFILLER_0_113_485 VPWR VGND VPWR VGND sky130_ef_sc_hd__decap_12
XFILLER_0_105_1269 VPWR VGND VPWR VGND sky130_ef_sc_hd__decap_12
XFILLER_0_41_1213 VPWR VGND VPWR VGND sky130_ef_sc_hd__decap_12
XFILLER_0_80_1295 VPWR VGND VPWR VGND sky130_ef_sc_hd__decap_12
XFILLER_0_220_1173 VPWR VGND VPWR VGND sky130_ef_sc_hd__decap_12
XFILLER_0_209_39 VGND VGND VPWR VPWR sky130_fd_sc_hd__decap_8
XFILLER_0_41_1279 VPWR VGND VPWR VGND sky130_ef_sc_hd__decap_12
XFILLER_0_215_559 VGND VGND VPWR VPWR sky130_fd_sc_hd__fill_1
XFILLER_0_218_1091 VGND VGND VPWR VPWR sky130_fd_sc_hd__fill_1
XFILLER_0_211_721 VGND VGND VPWR VPWR sky130_fd_sc_hd__decap_6
XFILLER_0_151_1201 VPWR VGND VPWR VGND sky130_ef_sc_hd__decap_12
XFILLER_0_116_1343 VGND VGND VPWR VPWR sky130_fd_sc_hd__fill_1
XFILLER_0_190_1283 VPWR VGND VPWR VGND sky130_ef_sc_hd__decap_12
XFILLER_0_211_765 VPWR VGND VPWR VGND sky130_ef_sc_hd__decap_12
XFILLER_0_210_253 VPWR VGND VPWR VGND sky130_ef_sc_hd__decap_12
XPHY_401 VGND VGND VPWR VPWR sky130_fd_sc_hd__decap_3
XFILLER_0_52_1331 VGND VGND VPWR VPWR sky130_fd_sc_hd__decap_6
XFILLER_0_183_617 VPWR VGND VPWR VGND sky130_ef_sc_hd__decap_12
XFILLER_0_151_1267 VPWR VGND VPWR VGND sky130_ef_sc_hd__decap_12
XFILLER_0_112_1229 VPWR VGND VPWR VGND sky130_ef_sc_hd__decap_12
XPHY_412 VGND VGND VPWR VPWR sky130_fd_sc_hd__decap_3
XPHY_423 VGND VGND VPWR VPWR sky130_fd_sc_hd__decap_3
XPHY_434 VGND VGND VPWR VPWR sky130_fd_sc_hd__decap_3
XFILLER_0_186_1319 VPWR VGND VPWR VGND sky130_ef_sc_hd__decap_12
XPHY_1000 VGND VGND VPWR VPWR sky130_fd_sc_hd__decap_3
XPHY_1011 VGND VGND VPWR VPWR sky130_fd_sc_hd__decap_3
XPHY_1022 VGND VGND VPWR VPWR sky130_fd_sc_hd__decap_3
XPHY_467 VGND VGND VPWR VPWR sky130_fd_sc_hd__decap_3
XPHY_445 VGND VGND VPWR VPWR sky130_fd_sc_hd__decap_3
XPHY_456 VGND VGND VPWR VPWR sky130_fd_sc_hd__decap_3
XPHY_1044 VGND VGND VPWR VPWR sky130_fd_sc_hd__decap_3
XPHY_1033 VGND VGND VPWR VPWR sky130_fd_sc_hd__decap_3
XPHY_1055 VGND VGND VPWR VPWR sky130_fd_sc_hd__decap_3
XPHY_478 VGND VGND VPWR VPWR sky130_fd_sc_hd__decap_3
XFILLER_0_4_1173 VPWR VGND VPWR VGND sky130_ef_sc_hd__decap_12
XPHY_489 VGND VGND VPWR VPWR sky130_fd_sc_hd__decap_3
XPHY_1099 VGND VGND VPWR VPWR sky130_fd_sc_hd__decap_3
XPHY_1066 VGND VGND VPWR VPWR sky130_fd_sc_hd__decap_3
XPHY_1088 VGND VGND VPWR VPWR sky130_fd_sc_hd__decap_3
XPHY_1077 VGND VGND VPWR VPWR sky130_fd_sc_hd__decap_3
XFILLER_0_105_953 VPWR VGND VPWR VGND sky130_ef_sc_hd__decap_12
XFILLER_0_123_1303 VGND VGND VPWR VPWR sky130_fd_sc_hd__decap_6
XFILLER_0_1_609 VGND VGND VPWR VPWR sky130_fd_sc_hd__decap_6
XFILLER_0_0_119 VPWR VGND VPWR VGND sky130_ef_sc_hd__decap_12
XFILLER_0_219_821 VPWR VGND VPWR VGND sky130_ef_sc_hd__decap_12
XFILLER_0_219_865 VPWR VGND VPWR VGND sky130_ef_sc_hd__decap_12
XFILLER_0_20_1319 VPWR VGND VPWR VGND sky130_ef_sc_hd__decap_12
XFILLER_0_185_9 VGND VGND VPWR VPWR sky130_fd_sc_hd__fill_2
XFILLER_0_221_529 VPWR VGND VPWR VGND sky130_ef_sc_hd__decap_12
XFILLER_0_57_1253 VGND VGND VPWR VPWR sky130_fd_sc_hd__fill_1
XFILLER_0_135_27 VPWR VGND VPWR VGND sky130_ef_sc_hd__decap_12
XFILLER_0_214_581 VGND VGND VPWR VPWR sky130_fd_sc_hd__decap_6
XFILLER_0_159_647 VGND VGND VPWR VPWR sky130_fd_sc_hd__decap_8
XFILLER_0_215_93 VPWR VGND VPWR VGND sky130_ef_sc_hd__decap_12
XFILLER_0_130_1307 VPWR VGND VPWR VGND sky130_ef_sc_hd__decap_12
XFILLER_0_174_617 VGND VGND VPWR VPWR sky130_fd_sc_hd__fill_1
XFILLER_0_57_645 VGND VGND VPWR VPWR sky130_fd_sc_hd__fill_1
XFILLER_0_151_15 VPWR VGND VPWR VGND sky130_ef_sc_hd__decap_12
XPHY_990 VGND VGND VPWR VPWR sky130_fd_sc_hd__decap_3
XFILLER_0_114_3 VGND VGND VPWR VPWR sky130_fd_sc_hd__fill_2
XFILLER_0_128_1225 VGND VGND VPWR VPWR sky130_fd_sc_hd__fill_1
XFILLER_0_29_1311 VPWR VGND VPWR VGND sky130_ef_sc_hd__decap_12
XFILLER_0_64_1213 VPWR VGND VPWR VGND sky130_ef_sc_hd__decap_12
XFILLER_0_114_249 VGND VGND VPWR VPWR sky130_fd_sc_hd__decap_3
XFILLER_0_4_469 VGND VGND VPWR VPWR sky130_fd_sc_hd__decap_6
XFILLER_0_111_945 VGND VGND VPWR VPWR sky130_fd_sc_hd__decap_6
XFILLER_0_100_41 VGND VGND VPWR VPWR sky130_fd_sc_hd__decap_8
XFILLER_0_110_433 VPWR VGND VPWR VGND sky130_ef_sc_hd__decap_12
XFILLER_0_111_989 VPWR VGND VPWR VGND sky130_ef_sc_hd__decap_12
XFILLER_0_99_1309 VGND VGND VPWR VPWR sky130_fd_sc_hd__fill_1
XFILLER_0_110_477 VPWR VGND VPWR VGND sky130_ef_sc_hd__decap_12
XFILLER_0_224_301 VGND VGND VPWR VPWR sky130_fd_sc_hd__decap_6
XFILLER_0_224_345 VPWR VGND VPWR VGND sky130_ef_sc_hd__decap_12
XFILLER_0_174_1201 VPWR VGND VPWR VGND sky130_ef_sc_hd__decap_12
XFILLER_0_139_1343 VGND VGND VPWR VPWR sky130_fd_sc_hd__fill_1
XANTENNA_u_pe11_act_in[2] act_10_out_11_in\[2\] VGND VGND VPWR VPWR sky130_fd_sc_hd__diode_2
XFILLER_0_224_389 VPWR VGND VPWR VGND sky130_ef_sc_hd__decap_12
XFILLER_0_215_1231 VGND VGND VPWR VPWR sky130_fd_sc_hd__fill_1
XFILLER_0_19_3 VPWR VGND VPWR VGND sky130_ef_sc_hd__decap_12
XFILLER_0_36_1337 VGND VGND VPWR VPWR sky130_fd_sc_hd__fill_1
XFILLER_0_165_617 VPWR VGND VPWR VGND sky130_ef_sc_hd__decap_12
XFILLER_0_1_1313 VPWR VGND VPWR VGND sky130_ef_sc_hd__decap_12
XFILLER_0_105_205 VPWR VGND VPWR VGND sky130_ef_sc_hd__decap_12
XFILLER_0_105_249 VPWR VGND VPWR VGND sky130_ef_sc_hd__decap_12
XFILLER_0_181_1249 VGND VGND VPWR VPWR sky130_fd_sc_hd__decap_4
XANTENNA_u_pe01_weight_in[9] net132 VGND VGND VPWR VPWR sky130_fd_sc_hd__diode_2
XFILLER_0_4_981 VPWR VGND VPWR VGND sky130_ef_sc_hd__decap_12
XFILLER_0_105_1033 VPWR VGND VPWR VGND sky130_ef_sc_hd__decap_12
XFILLER_0_113_293 VPWR VGND VPWR VGND sky130_ef_sc_hd__decap_12
XFILLER_0_105_1077 VPWR VGND VPWR VGND sky130_ef_sc_hd__decap_12
XFILLER_0_216_813 VPWR VGND VPWR VGND sky130_ef_sc_hd__decap_12
XFILLER_0_216_1017 VPWR VGND VPWR VGND sky130_ef_sc_hd__decap_12
XFILLER_0_211_573 VPWR VGND VPWR VGND sky130_ef_sc_hd__decap_12
XFILLER_0_156_617 VGND VGND VPWR VPWR sky130_fd_sc_hd__fill_1
XFILLER_0_39_645 VGND VGND VPWR VPWR sky130_fd_sc_hd__fill_1
XFILLER_0_112_1037 VPWR VGND VPWR VGND sky130_ef_sc_hd__decap_12
XPHY_220 VGND VGND VPWR VPWR sky130_fd_sc_hd__decap_3
XPHY_231 VGND VGND VPWR VPWR sky130_fd_sc_hd__decap_3
XPHY_242 VGND VGND VPWR VPWR sky130_fd_sc_hd__decap_3
XPHY_286 VGND VGND VPWR VPWR sky130_fd_sc_hd__decap_3
XPHY_275 VGND VGND VPWR VPWR sky130_fd_sc_hd__decap_3
XPHY_264 VGND VGND VPWR VPWR sky130_fd_sc_hd__decap_3
XPHY_253 VGND VGND VPWR VPWR sky130_fd_sc_hd__decap_3
XFILLER_0_87_1213 VPWR VGND VPWR VGND sky130_ef_sc_hd__decap_12
XFILLER_0_30_27 VGND VGND VPWR VPWR sky130_fd_sc_hd__fill_1
XPHY_297 VGND VGND VPWR VPWR sky130_fd_sc_hd__decap_3
XFILLER_0_30_49 VGND VGND VPWR VPWR sky130_fd_sc_hd__fill_1
XFILLER_0_87_1279 VPWR VGND VPWR VGND sky130_ef_sc_hd__decap_12
XFILLER_0_1_417 VPWR VGND VPWR VGND sky130_ef_sc_hd__decap_12
XFILLER_0_105_783 VGND VGND VPWR VPWR sky130_fd_sc_hd__fill_1
XFILLER_0_197_1201 VPWR VGND VPWR VGND sky130_ef_sc_hd__decap_12
XFILLER_0_127_1291 VPWR VGND VPWR VGND sky130_ef_sc_hd__decap_12
XFILLER_0_39_47 VGND VGND VPWR VPWR sky130_fd_sc_hd__fill_1
XFILLER_0_104_293 VPWR VGND VPWR VGND sky130_ef_sc_hd__decap_12
XFILLER_0_24_1263 VPWR VGND VPWR VGND sky130_ef_sc_hd__decap_12
XFILLER_0_197_1267 VPWR VGND VPWR VGND sky130_ef_sc_hd__decap_12
XFILLER_0_219_673 VPWR VGND VPWR VGND sky130_ef_sc_hd__decap_12
XFILLER_0_98_1331 VGND VGND VPWR VPWR sky130_fd_sc_hd__decap_6
XFILLER_0_146_15 VPWR VGND VPWR VGND sky130_ef_sc_hd__decap_12
XFILLER_0_222_805 VGND VGND VPWR VPWR sky130_fd_sc_hd__decap_6
XFILLER_0_94_1239 VPWR VGND VPWR VGND sky130_ef_sc_hd__decap_12
XFILLER_0_222_849 VPWR VGND VPWR VGND sky130_ef_sc_hd__decap_12
XFILLER_0_221_337 VPWR VGND VPWR VGND sky130_ef_sc_hd__decap_12
XFILLER_0_134_1251 VPWR VGND VPWR VGND sky130_ef_sc_hd__decap_12
XFILLER_0_147_617 VPWR VGND VPWR VGND sky130_ef_sc_hd__decap_12
XFILLER_0_169_1303 VGND VGND VPWR VPWR sky130_fd_sc_hd__decap_6
XFILLER_0_134_1295 VPWR VGND VPWR VGND sky130_ef_sc_hd__decap_12
XFILLER_0_31_1201 VPWR VGND VPWR VGND sky130_ef_sc_hd__decap_12
XFILLER_0_210_1161 VGND VGND VPWR VPWR sky130_fd_sc_hd__fill_2
XFILLER_0_70_1283 VPWR VGND VPWR VGND sky130_ef_sc_hd__decap_12
XFILLER_0_31_1267 VPWR VGND VPWR VGND sky130_ef_sc_hd__decap_12
XFILLER_0_170_631 VPWR VGND VPWR VGND sky130_ef_sc_hd__decap_12
XFILLER_0_4_233 VPWR VGND VPWR VGND sky130_ef_sc_hd__decap_12
XFILLER_0_66_1319 VPWR VGND VPWR VGND sky130_ef_sc_hd__decap_12
XFILLER_0_111_51 VGND VGND VPWR VPWR sky130_fd_sc_hd__decap_4
XFILLER_0_4_277 VPWR VGND VPWR VGND sky130_ef_sc_hd__decap_12
XFILLER_0_111_753 VPWR VGND VPWR VGND sky130_ef_sc_hd__decap_12
XFILLER_0_1_951 VGND VGND VPWR VPWR sky130_fd_sc_hd__fill_1
XFILLER_0_141_1255 VPWR VGND VPWR VGND sky130_ef_sc_hd__decap_12
XFILLER_0_111_797 VPWR VGND VPWR VGND sky130_ef_sc_hd__decap_12
XFILLER_0_176_1307 VPWR VGND VPWR VGND sky130_ef_sc_hd__decap_12
XFILLER_0_216_109 VPWR VGND VPWR VGND sky130_ef_sc_hd__decap_12
XFILLER_0_102_1239 VPWR VGND VPWR VGND sky130_ef_sc_hd__decap_12
XFILLER_0_225_665 VGND VGND VPWR VPWR sky130_fd_sc_hd__decap_6
XFILLER_0_224_153 VPWR VGND VPWR VGND sky130_ef_sc_hd__decap_12
XFILLER_0_217_1337 VGND VGND VPWR VPWR sky130_fd_sc_hd__decap_6
XTAP_2607 VGND VPWR sky130_fd_sc_hd__tapvpwrvgnd_1
XFILLER_0_224_197 VPWR VGND VPWR VGND sky130_ef_sc_hd__decap_12
XTAP_2618 VGND VPWR sky130_fd_sc_hd__tapvpwrvgnd_1
XFILLER_0_206_29 VPWR VGND VPWR VGND sky130_ef_sc_hd__decap_12
XTAP_2629 VGND VPWR sky130_fd_sc_hd__tapvpwrvgnd_1
XTAP_1906 VGND VPWR sky130_fd_sc_hd__tapvpwrvgnd_1
XFILLER_0_113_1313 VPWR VGND VPWR VGND sky130_ef_sc_hd__decap_12
XTAP_1928 VGND VPWR sky130_fd_sc_hd__tapvpwrvgnd_1
XFILLER_0_138_617 VGND VGND VPWR VPWR sky130_fd_sc_hd__fill_1
XTAP_1917 VGND VPWR sky130_fd_sc_hd__tapvpwrvgnd_1
XTAP_1939 VGND VPWR sky130_fd_sc_hd__tapvpwrvgnd_1
XFILLER_0_10_1307 VPWR VGND VPWR VGND sky130_ef_sc_hd__decap_12
XFILLER_0_1_1121 VPWR VGND VPWR VGND sky130_ef_sc_hd__decap_12
XFILLER_0_106_525 VGND VGND VPWR VPWR sky130_fd_sc_hd__decap_6
XFILLER_0_51_629 VPWR VGND VPWR VGND sky130_ef_sc_hd__decap_12
XFILLER_0_106_569 VPWR VGND VPWR VGND sky130_ef_sc_hd__decap_12
XANTENNA_u_pe10_weight_in[11] net135 VGND VGND VPWR VPWR sky130_fd_sc_hd__diode_2
XANTENNA_input161_A w11[6] VGND VGND VPWR VPWR sky130_fd_sc_hd__diode_2
XFILLER_0_8_3 VPWR VGND VPWR VGND sky130_ef_sc_hd__decap_12
XFILLER_0_120_1339 VGND VGND VPWR VPWR sky130_fd_sc_hd__decap_4
XFILLER_0_216_643 VGND VGND VPWR VPWR sky130_fd_sc_hd__fill_1
XANTENNA_input22_A act_row1_in[14] VGND VGND VPWR VPWR sky130_fd_sc_hd__diode_2
XFILLER_0_118_1213 VPWR VGND VPWR VGND sky130_ef_sc_hd__decap_12
XFILLER_0_25_27 VPWR VGND VPWR VGND sky130_ef_sc_hd__decap_12
XFILLER_0_54_1201 VPWR VGND VPWR VGND sky130_ef_sc_hd__decap_12
XFILLER_0_116_29 VPWR VGND VPWR VGND sky130_ef_sc_hd__decap_12
XFILLER_0_8_1319 VPWR VGND VPWR VGND sky130_ef_sc_hd__decap_12
XFILLER_0_19_1343 VGND VGND VPWR VPWR sky130_fd_sc_hd__fill_1
XFILLER_0_212_893 VPWR VGND VPWR VGND sky130_ef_sc_hd__decap_12
XFILLER_0_129_617 VPWR VGND VPWR VGND sky130_ef_sc_hd__decap_12
XFILLER_0_41_15 VPWR VGND VPWR VGND sky130_ef_sc_hd__decap_12
XFILLER_0_212_83 VGND VGND VPWR VPWR sky130_fd_sc_hd__fill_1
XFILLER_0_152_631 VPWR VGND VPWR VGND sky130_ef_sc_hd__decap_12
XFILLER_0_109_385 VGND VGND VPWR VPWR sky130_fd_sc_hd__decap_6
XANTENNA_u_pe01_act_in[5] act_00_out_01_in\[5\] VGND VGND VPWR VPWR sky130_fd_sc_hd__diode_2
XFILLER_0_2_737 VPWR VGND VPWR VGND sky130_ef_sc_hd__decap_12
XFILLER_0_1_225 VPWR VGND VPWR VGND sky130_ef_sc_hd__decap_12
XFILLER_0_5_15 VPWR VGND VPWR VGND sky130_ef_sc_hd__decap_12
XFILLER_0_61_1249 VGND VGND VPWR VPWR sky130_fd_sc_hd__decap_4
XFILLER_0_181_3 VPWR VGND VPWR VGND sky130_ef_sc_hd__decap_12
XFILLER_0_222_613 VPWR VGND VPWR VGND sky130_ef_sc_hd__decap_12
XFILLER_0_222_657 VPWR VGND VPWR VGND sky130_ef_sc_hd__decap_12
XFILLER_0_171_1237 VPWR VGND VPWR VGND sky130_ef_sc_hd__decap_12
XFILLER_0_221_167 VGND VGND VPWR VPWR sky130_fd_sc_hd__fill_1
XFILLER_0_33_629 VPWR VGND VPWR VGND sky130_ef_sc_hd__decap_12
XFILLER_0_86_3 VPWR VGND VPWR VGND sky130_ef_sc_hd__decap_12
XFILLER_0_5_553 VGND VGND VPWR VPWR sky130_fd_sc_hd__decap_6
XFILLER_0_5_597 VPWR VGND VPWR VGND sky130_ef_sc_hd__decap_12
XFILLER_0_106_1161 VPWR VGND VPWR VGND sky130_ef_sc_hd__decap_12
XFILLER_0_111_561 VPWR VGND VPWR VGND sky130_ef_sc_hd__decap_12
XFILLER_0_217_429 VPWR VGND VPWR VGND sky130_ef_sc_hd__decap_12
XFILLER_0_226_930 VGND VGND VPWR VPWR sky130_fd_sc_hd__fill_2
XFILLER_0_77_1201 VPWR VGND VPWR VGND sky130_ef_sc_hd__decap_12
XFILLER_0_217_1101 VPWR VGND VPWR VGND sky130_ef_sc_hd__decap_12
XFILLER_0_226_974 VGND VGND VPWR VPWR sky130_fd_sc_hd__decap_6
XFILLER_0_226_996 VPWR VGND VPWR VGND sky130_ef_sc_hd__decap_12
XFILLER_0_225_473 VPWR VGND VPWR VGND sky130_ef_sc_hd__decap_12
XFILLER_0_77_1267 VPWR VGND VPWR VGND sky130_ef_sc_hd__decap_12
XFILLER_0_217_1145 VPWR VGND VPWR VGND sky130_ef_sc_hd__decap_12
XFILLER_0_213_1009 VPWR VGND VPWR VGND sky130_ef_sc_hd__decap_12
XTAP_2415 VGND VPWR sky130_fd_sc_hd__tapvpwrvgnd_1
XTAP_2404 VGND VPWR sky130_fd_sc_hd__tapvpwrvgnd_1
XTAP_2426 VGND VPWR sky130_fd_sc_hd__tapvpwrvgnd_1
XFILLER_0_217_1189 VPWR VGND VPWR VGND sky130_ef_sc_hd__decap_12
XTAP_2459 VGND VPWR sky130_fd_sc_hd__tapvpwrvgnd_1
XTAP_2448 VGND VPWR sky130_fd_sc_hd__tapvpwrvgnd_1
XTAP_2437 VGND VPWR sky130_fd_sc_hd__tapvpwrvgnd_1
XFILLER_0_212_189 VGND VGND VPWR VPWR sky130_fd_sc_hd__decap_6
XTAP_1725 VGND VPWR sky130_fd_sc_hd__tapvpwrvgnd_1
XTAP_1714 VGND VPWR sky130_fd_sc_hd__tapvpwrvgnd_1
XTAP_1703 VGND VPWR sky130_fd_sc_hd__tapvpwrvgnd_1
XFILLER_0_113_1121 VPWR VGND VPWR VGND sky130_ef_sc_hd__decap_12
XTAP_1758 VGND VPWR sky130_fd_sc_hd__tapvpwrvgnd_1
XFILLER_0_7_1341 VGND VGND VPWR VPWR sky130_fd_sc_hd__decap_3
XTAP_1736 VGND VPWR sky130_fd_sc_hd__tapvpwrvgnd_1
XTAP_1747 VGND VPWR sky130_fd_sc_hd__tapvpwrvgnd_1
XFILLER_0_14_1251 VPWR VGND VPWR VGND sky130_ef_sc_hd__decap_12
XTAP_1769 VGND VPWR sky130_fd_sc_hd__tapvpwrvgnd_1
XFILLER_0_187_1255 VPWR VGND VPWR VGND sky130_ef_sc_hd__decap_12
XFILLER_0_148_1239 VPWR VGND VPWR VGND sky130_ef_sc_hd__decap_12
XFILLER_0_134_631 VPWR VGND VPWR VGND sky130_ef_sc_hd__decap_12
XFILLER_0_14_1295 VPWR VGND VPWR VGND sky130_ef_sc_hd__decap_12
XFILLER_0_49_1303 VGND VGND VPWR VPWR sky130_fd_sc_hd__decap_6
XFILLER_0_107_889 VGND VGND VPWR VPWR sky130_fd_sc_hd__decap_6
XFILLER_0_84_1227 VPWR VGND VPWR VGND sky130_ef_sc_hd__decap_12
XFILLER_0_106_333 VPWR VGND VPWR VGND sky130_ef_sc_hd__decap_12
XFILLER_0_224_1105 VPWR VGND VPWR VGND sky130_ef_sc_hd__decap_12
XFILLER_0_106_377 VPWR VGND VPWR VGND sky130_ef_sc_hd__decap_12
XFILLER_0_224_1149 VPWR VGND VPWR VGND sky130_ef_sc_hd__decap_12
XFILLER_0_124_1283 VPWR VGND VPWR VGND sky130_ef_sc_hd__decap_12
XFILLER_0_159_1335 VGND VGND VPWR VPWR sky130_fd_sc_hd__decap_8
XFILLER_0_95_1323 VPWR VGND VPWR VGND sky130_ef_sc_hd__decap_12
XFILLER_0_36_15 VPWR VGND VPWR VGND sky130_ef_sc_hd__decap_12
XFILLER_0_21_1255 VPWR VGND VPWR VGND sky130_ef_sc_hd__decap_12
XFILLER_0_127_39 VGND VGND VPWR VPWR sky130_fd_sc_hd__decap_8
XFILLER_0_56_1307 VPWR VGND VPWR VGND sky130_ef_sc_hd__decap_12
XTAP_2960 VGND VPWR sky130_fd_sc_hd__tapvpwrvgnd_1
XFILLER_0_52_25 VGND VGND VPWR VPWR sky130_fd_sc_hd__decap_3
XFILLER_0_170_1281 VGND VGND VPWR VPWR sky130_fd_sc_hd__fill_1
XFILLER_0_223_93 VPWR VGND VPWR VGND sky130_ef_sc_hd__decap_12
XANTENNA_u_pe11_clk clknet_1_0__leaf_clk VGND VGND VPWR VPWR sky130_fd_sc_hd__diode_2
XFILLER_0_166_1339 VGND VGND VPWR VPWR sky130_fd_sc_hd__decap_4
XFILLER_0_207_1303 VGND VGND VPWR VPWR sky130_fd_sc_hd__decap_6
XFILLER_0_15_629 VPWR VGND VPWR VGND sky130_ef_sc_hd__decap_12
XFILLER_0_109_193 VPWR VGND VPWR VGND sky130_ef_sc_hd__decap_12
XFILLER_0_2_501 VPWR VGND VPWR VGND sky130_ef_sc_hd__decap_12
XFILLER_0_2_545 VPWR VGND VPWR VGND sky130_ef_sc_hd__decap_12
XFILLER_0_2_589 VPWR VGND VPWR VGND sky130_ef_sc_hd__decap_12
XFILLER_0_77_22 VPWR VGND VPWR VGND sky130_ef_sc_hd__decap_12
XFILLER_0_226_204 VPWR VGND VPWR VGND sky130_ef_sc_hd__decap_12
XFILLER_0_103_1323 VPWR VGND VPWR VGND sky130_ef_sc_hd__decap_12
XFILLER_0_226_248 VGND VGND VPWR VPWR sky130_fd_sc_hd__decap_4
XFILLER_0_223_933 VPWR VGND VPWR VGND sky130_ef_sc_hd__decap_12
XFILLER_0_223_977 VPWR VGND VPWR VGND sky130_ef_sc_hd__decap_12
XFILLER_0_222_421 VPWR VGND VPWR VGND sky130_ef_sc_hd__decap_12
XFILLER_0_214_1329 VPWR VGND VPWR VGND sky130_ef_sc_hd__decap_12
XPHY_808 VGND VGND VPWR VPWR sky130_fd_sc_hd__decap_3
XPHY_819 VGND VGND VPWR VPWR sky130_fd_sc_hd__decap_3
XFILLER_0_116_631 VPWR VGND VPWR VGND sky130_ef_sc_hd__decap_12
XFILLER_0_104_837 VGND VGND VPWR VPWR sky130_fd_sc_hd__decap_3
XFILLER_0_5_361 VPWR VGND VPWR VGND sky130_ef_sc_hd__decap_12
XFILLER_0_131_645 VGND VGND VPWR VPWR sky130_fd_sc_hd__fill_1
XFILLER_0_112_881 VPWR VGND VPWR VGND sky130_ef_sc_hd__decap_12
XFILLER_0_218_749 VGND VGND VPWR VPWR sky130_fd_sc_hd__decap_6
XFILLER_0_217_237 VPWR VGND VPWR VGND sky130_ef_sc_hd__decap_12
XFILLER_0_111_391 VGND VGND VPWR VPWR sky130_fd_sc_hd__fill_1
XFILLER_0_225_281 VPWR VGND VPWR VGND sky130_ef_sc_hd__decap_12
XANTENNA_input124_A w01[1] VGND VGND VPWR VPWR sky130_fd_sc_hd__diode_2
XTAP_2201 VGND VPWR sky130_fd_sc_hd__tapvpwrvgnd_1
XFILLER_0_201_605 VPWR VGND VPWR VGND sky130_ef_sc_hd__decap_12
XTAP_2223 VGND VPWR sky130_fd_sc_hd__tapvpwrvgnd_1
XTAP_2212 VGND VPWR sky130_fd_sc_hd__tapvpwrvgnd_1
XTAP_2234 VGND VPWR sky130_fd_sc_hd__tapvpwrvgnd_1
XTAP_2267 VGND VPWR sky130_fd_sc_hd__tapvpwrvgnd_1
XTAP_2256 VGND VPWR sky130_fd_sc_hd__tapvpwrvgnd_1
XTAP_2245 VGND VPWR sky130_fd_sc_hd__tapvpwrvgnd_1
XFILLER_0_115_1249 VGND VGND VPWR VPWR sky130_fd_sc_hd__decap_4
XTAP_2278 VGND VPWR sky130_fd_sc_hd__tapvpwrvgnd_1
XFILLER_0_96_643 VPWR VGND VPWR VGND sky130_ef_sc_hd__decap_12
XTAP_1533 VGND VPWR sky130_fd_sc_hd__tapvpwrvgnd_1
XPHY_40 VGND VGND VPWR VPWR sky130_fd_sc_hd__decap_3
XTAP_1522 VGND VPWR sky130_fd_sc_hd__tapvpwrvgnd_1
XTAP_1500 VGND VPWR sky130_fd_sc_hd__tapvpwrvgnd_1
XTAP_1511 VGND VPWR sky130_fd_sc_hd__tapvpwrvgnd_1
XFILLER_0_90_1275 VGND VGND VPWR VPWR sky130_fd_sc_hd__decap_6
XPHY_73 VGND VGND VPWR VPWR sky130_fd_sc_hd__decap_3
XTAP_1566 VGND VPWR sky130_fd_sc_hd__tapvpwrvgnd_1
XPHY_51 VGND VGND VPWR VPWR sky130_fd_sc_hd__decap_3
XPHY_62 VGND VGND VPWR VPWR sky130_fd_sc_hd__decap_3
XTAP_1544 VGND VPWR sky130_fd_sc_hd__tapvpwrvgnd_1
XTAP_1555 VGND VPWR sky130_fd_sc_hd__tapvpwrvgnd_1
XFILLER_0_51_1237 VPWR VGND VPWR VGND sky130_ef_sc_hd__decap_12
XTAP_2289 VGND VPWR sky130_fd_sc_hd__tapvpwrvgnd_1
XPHY_95 VGND VGND VPWR VPWR sky130_fd_sc_hd__decap_3
XPHY_84 VGND VGND VPWR VPWR sky130_fd_sc_hd__decap_3
XTAP_1577 VGND VPWR sky130_fd_sc_hd__tapvpwrvgnd_1
XTAP_1588 VGND VPWR sky130_fd_sc_hd__tapvpwrvgnd_1
XTAP_1599 VGND VPWR sky130_fd_sc_hd__tapvpwrvgnd_1
XFILLER_0_3_1057 VGND VGND VPWR VPWR sky130_fd_sc_hd__decap_6
XFILLER_0_109_1009 VPWR VGND VPWR VGND sky130_ef_sc_hd__decap_12
XFILLER_0_107_653 VPWR VGND VPWR VGND sky130_ef_sc_hd__decap_12
XFILLER_0_106_141 VPWR VGND VPWR VGND sky130_ef_sc_hd__decap_12
XFILLER_0_107_697 VPWR VGND VPWR VGND sky130_ef_sc_hd__decap_12
XFILLER_0_161_1225 VPWR VGND VPWR VGND sky130_ef_sc_hd__decap_12
XFILLER_0_20_643 VPWR VGND VPWR VGND sky130_ef_sc_hd__decap_12
XFILLER_0_138_27 VGND VGND VPWR VPWR sky130_fd_sc_hd__fill_1
XFILLER_0_138_49 VGND VGND VPWR VPWR sky130_fd_sc_hd__fill_1
XFILLER_0_47_47 VGND VGND VPWR VPWR sky130_fd_sc_hd__fill_1
XFILLER_0_189_645 VGND VGND VPWR VPWR sky130_fd_sc_hd__fill_1
XFILLER_0_2_27 VGND VGND VPWR VPWR sky130_fd_sc_hd__fill_1
XFILLER_0_220_925 VPWR VGND VPWR VGND sky130_ef_sc_hd__decap_12
XFILLER_0_172_1343 VGND VGND VPWR VPWR sky130_fd_sc_hd__fill_1
XFILLER_0_63_46 VGND VGND VPWR VPWR sky130_fd_sc_hd__decap_4
XTAP_2790 VGND VPWR sky130_fd_sc_hd__tapvpwrvgnd_1
XFILLER_0_144_3 VPWR VGND VPWR VGND sky130_ef_sc_hd__decap_12
XFILLER_0_3_821 VPWR VGND VPWR VGND sky130_ef_sc_hd__decap_12
XFILLER_0_67_1255 VPWR VGND VPWR VGND sky130_ef_sc_hd__decap_12
XFILLER_0_3_865 VPWR VGND VPWR VGND sky130_ef_sc_hd__decap_12
XFILLER_0_70_6 VGND VGND VPWR VPWR sky130_fd_sc_hd__fill_2
XFILLER_0_28_1239 VPWR VGND VPWR VGND sky130_ef_sc_hd__decap_12
XFILLER_0_112_133 VGND VGND VPWR VPWR sky130_fd_sc_hd__decap_6
Xoutput167 net167 VGND VGND VPWR VPWR psum_col0_out[11] sky130_fd_sc_hd__clkbuf_4
XFILLER_0_112_177 VPWR VGND VPWR VGND sky130_ef_sc_hd__decap_12
Xoutput189 net189 VGND VGND VPWR VPWR psum_col0_out[31] sky130_fd_sc_hd__clkbuf_4
Xoutput178 net178 VGND VGND VPWR VPWR psum_col0_out[21] sky130_fd_sc_hd__clkbuf_4
XFILLER_0_138_1227 VPWR VGND VPWR VGND sky130_ef_sc_hd__decap_12
XFILLER_0_223_741 VPWR VGND VPWR VGND sky130_ef_sc_hd__decap_12
XFILLER_0_39_1335 VGND VGND VPWR VPWR sky130_fd_sc_hd__decap_8
XFILLER_0_218_1273 VPWR VGND VPWR VGND sky130_ef_sc_hd__decap_12
XFILLER_0_223_785 VPWR VGND VPWR VGND sky130_ef_sc_hd__decap_12
XFILLER_0_222_251 VGND VGND VPWR VPWR sky130_fd_sc_hd__fill_1
XFILLER_0_214_29 VPWR VGND VPWR VGND sky130_ef_sc_hd__decap_12
XFILLER_0_78_643 VPWR VGND VPWR VGND sky130_ef_sc_hd__decap_12
XPHY_605 VGND VGND VPWR VPWR sky130_fd_sc_hd__decap_3
XPHY_616 VGND VGND VPWR VPWR sky130_fd_sc_hd__decap_3
XPHY_1204 VGND VGND VPWR VPWR sky130_fd_sc_hd__decap_3
XPHY_649 VGND VGND VPWR VPWR sky130_fd_sc_hd__decap_3
XPHY_627 VGND VGND VPWR VPWR sky130_fd_sc_hd__decap_3
XPHY_638 VGND VGND VPWR VPWR sky130_fd_sc_hd__decap_3
XPHY_1215 VGND VGND VPWR VPWR sky130_fd_sc_hd__decap_3
XFILLER_0_149_1323 VPWR VGND VPWR VGND sky130_ef_sc_hd__decap_12
XFILLER_0_0_1219 VGND VGND VPWR VPWR sky130_fd_sc_hd__decap_8
XFILLER_0_50_1281 VGND VGND VPWR VPWR sky130_fd_sc_hd__fill_1
XFILLER_0_184_1225 VGND VGND VPWR VPWR sky130_fd_sc_hd__fill_1
XFILLER_0_85_1311 VPWR VGND VPWR VGND sky130_ef_sc_hd__decap_12
XFILLER_0_104_601 VPWR VGND VPWR VGND sky130_ef_sc_hd__decap_12
XFILLER_0_6_681 VPWR VGND VPWR VGND sky130_ef_sc_hd__decap_12
XFILLER_0_225_1233 VPWR VGND VPWR VGND sky130_ef_sc_hd__decap_12
XFILLER_0_104_645 VPWR VGND VPWR VGND sky130_ef_sc_hd__decap_12
XFILLER_0_46_1339 VGND VGND VPWR VPWR sky130_fd_sc_hd__decap_4
XFILLER_0_221_1119 VGND VGND VPWR VPWR sky130_fd_sc_hd__fill_1
XFILLER_0_218_513 VPWR VGND VPWR VGND sky130_ef_sc_hd__decap_12
XFILLER_0_218_557 VPWR VGND VPWR VGND sky130_ef_sc_hd__decap_12
XFILLER_0_121_1253 VGND VGND VPWR VPWR sky130_fd_sc_hd__fill_1
XFILLER_0_195_1343 VGND VGND VPWR VPWR sky130_fd_sc_hd__fill_1
XFILLER_0_92_1337 VGND VGND VPWR VPWR sky130_fd_sc_hd__fill_1
XFILLER_0_213_273 VGND VGND VPWR VPWR sky130_fd_sc_hd__decap_6
XTAP_2020 VGND VPWR sky130_fd_sc_hd__tapvpwrvgnd_1
XTAP_2042 VGND VPWR sky130_fd_sc_hd__tapvpwrvgnd_1
XFILLER_0_9_1255 VPWR VGND VPWR VGND sky130_ef_sc_hd__decap_12
XTAP_2031 VGND VPWR sky130_fd_sc_hd__tapvpwrvgnd_1
XFILLER_0_124_29 VPWR VGND VPWR VGND sky130_ef_sc_hd__decap_12
XTAP_2086 VGND VPWR sky130_fd_sc_hd__tapvpwrvgnd_1
XTAP_2064 VGND VPWR sky130_fd_sc_hd__tapvpwrvgnd_1
XFILLER_0_33_27 VPWR VGND VPWR VGND sky130_ef_sc_hd__decap_12
XTAP_1341 VGND VPWR sky130_fd_sc_hd__tapvpwrvgnd_1
XTAP_1330 VGND VPWR sky130_fd_sc_hd__tapvpwrvgnd_1
XFILLER_0_5_1119 VGND VGND VPWR VPWR sky130_fd_sc_hd__fill_1
XTAP_2075 VGND VPWR sky130_fd_sc_hd__tapvpwrvgnd_1
XTAP_2053 VGND VPWR sky130_fd_sc_hd__tapvpwrvgnd_1
XTAP_1363 VGND VPWR sky130_fd_sc_hd__tapvpwrvgnd_1
XTAP_1374 VGND VPWR sky130_fd_sc_hd__tapvpwrvgnd_1
XTAP_1352 VGND VPWR sky130_fd_sc_hd__tapvpwrvgnd_1
XTAP_2097 VGND VPWR sky130_fd_sc_hd__tapvpwrvgnd_1
XTAP_1385 VGND VPWR sky130_fd_sc_hd__tapvpwrvgnd_1
XTAP_1396 VGND VPWR sky130_fd_sc_hd__tapvpwrvgnd_1
Xinput36 psum_col0_in[11] VGND VGND VPWR VPWR net36 sky130_fd_sc_hd__buf_1
XFILLER_0_163_1309 VGND VGND VPWR VPWR sky130_fd_sc_hd__fill_1
XFILLER_0_108_973 VGND VGND VPWR VPWR sky130_fd_sc_hd__decap_6
Xinput25 act_row1_in[2] VGND VGND VPWR VPWR net25 sky130_fd_sc_hd__buf_1
Xinput14 act_row0_in[7] VGND VGND VPWR VPWR net14 sky130_fd_sc_hd__clkbuf_4
XFILLER_0_107_461 VPWR VGND VPWR VGND sky130_ef_sc_hd__decap_12
Xinput69 psum_col1_in[12] VGND VGND VPWR VPWR net69 sky130_fd_sc_hd__buf_1
Xinput58 psum_col0_in[31] VGND VGND VPWR VPWR net58 sky130_fd_sc_hd__buf_1
Xinput47 psum_col0_in[21] VGND VGND VPWR VPWR net47 sky130_fd_sc_hd__buf_1
XFILLER_0_220_83 VGND VGND VPWR VPWR sky130_fd_sc_hd__fill_1
XFILLER_0_0_813 VGND VGND VPWR VPWR sky130_fd_sc_hd__decap_4
XFILLER_0_149_15 VPWR VGND VPWR VGND sky130_ef_sc_hd__decap_12
XFILLER_0_204_1339 VGND VGND VPWR VPWR sky130_fd_sc_hd__decap_4
XFILLER_0_110_637 VGND VGND VPWR VPWR sky130_fd_sc_hd__decap_6
XFILLER_0_0_835 VGND VGND VPWR VPWR sky130_fd_sc_hd__decap_4
XFILLER_0_97_1237 VPWR VGND VPWR VGND sky130_ef_sc_hd__decap_12
XFILLER_0_100_1337 VGND VGND VPWR VPWR sky130_fd_sc_hd__fill_1
XFILLER_0_35_9 VGND VGND VPWR VPWR sky130_fd_sc_hd__fill_2
XFILLER_0_165_47 VGND VGND VPWR VPWR sky130_fd_sc_hd__fill_1
XFILLER_0_220_755 VGND VGND VPWR VPWR sky130_fd_sc_hd__fill_1
XFILLER_0_90_605 VPWR VGND VPWR VGND sky130_ef_sc_hd__decap_12
XFILLER_0_7_445 VGND VGND VPWR VPWR sky130_fd_sc_hd__decap_3
XFILLER_0_114_921 VGND VGND VPWR VPWR sky130_fd_sc_hd__decap_3
XFILLER_0_7_489 VPWR VGND VPWR VGND sky130_ef_sc_hd__decap_12
XFILLER_0_183_1291 VPWR VGND VPWR VGND sky130_ef_sc_hd__decap_12
XFILLER_0_114_965 VPWR VGND VPWR VGND sky130_ef_sc_hd__decap_12
XFILLER_0_3_673 VPWR VGND VPWR VGND sky130_ef_sc_hd__decap_12
XFILLER_0_144_1275 VGND VGND VPWR VPWR sky130_fd_sc_hd__decap_6
XFILLER_0_113_497 VGND VGND VPWR VPWR sky130_fd_sc_hd__decap_6
XFILLER_0_220_1141 VGND VGND VPWR VPWR sky130_fd_sc_hd__decap_6
XFILLER_0_41_1225 VPWR VGND VPWR VGND sky130_ef_sc_hd__decap_12
XFILLER_0_80_1263 VPWR VGND VPWR VGND sky130_ef_sc_hd__decap_12
XFILLER_0_220_1185 VPWR VGND VPWR VGND sky130_ef_sc_hd__decap_12
XFILLER_0_215_505 VPWR VGND VPWR VGND sky130_ef_sc_hd__decap_12
XFILLER_0_3_81 VPWR VGND VPWR VGND sky130_ef_sc_hd__decap_12
XFILLER_0_190_1251 VPWR VGND VPWR VGND sky130_ef_sc_hd__decap_12
XFILLER_0_151_1213 VPWR VGND VPWR VGND sky130_ef_sc_hd__decap_12
XFILLER_0_190_1295 VPWR VGND VPWR VGND sky130_ef_sc_hd__decap_12
XFILLER_0_211_777 VGND VGND VPWR VPWR sky130_fd_sc_hd__decap_6
XFILLER_0_210_221 VGND VGND VPWR VPWR sky130_fd_sc_hd__decap_3
XFILLER_0_183_629 VPWR VGND VPWR VGND sky130_ef_sc_hd__decap_12
XFILLER_0_210_265 VPWR VGND VPWR VGND sky130_ef_sc_hd__decap_12
XFILLER_0_151_1279 VPWR VGND VPWR VGND sky130_ef_sc_hd__decap_12
XPHY_424 VGND VGND VPWR VPWR sky130_fd_sc_hd__decap_3
XPHY_413 VGND VGND VPWR VPWR sky130_fd_sc_hd__decap_3
XPHY_402 VGND VGND VPWR VPWR sky130_fd_sc_hd__decap_3
XFILLER_0_52_1343 VGND VGND VPWR VPWR sky130_fd_sc_hd__fill_1
XPHY_435 VGND VGND VPWR VPWR sky130_fd_sc_hd__decap_3
XPHY_1012 VGND VGND VPWR VPWR sky130_fd_sc_hd__decap_3
XPHY_1001 VGND VGND VPWR VPWR sky130_fd_sc_hd__decap_3
XPHY_1023 VGND VGND VPWR VPWR sky130_fd_sc_hd__decap_3
XFILLER_0_81_605 VPWR VGND VPWR VGND sky130_ef_sc_hd__decap_12
XPHY_457 VGND VGND VPWR VPWR sky130_fd_sc_hd__decap_3
XPHY_468 VGND VGND VPWR VPWR sky130_fd_sc_hd__decap_3
XFILLER_0_4_1141 VGND VGND VPWR VPWR sky130_fd_sc_hd__decap_6
XPHY_446 VGND VGND VPWR VPWR sky130_fd_sc_hd__decap_3
XPHY_1056 VGND VGND VPWR VPWR sky130_fd_sc_hd__decap_3
XPHY_1045 VGND VGND VPWR VPWR sky130_fd_sc_hd__decap_3
XPHY_1034 VGND VGND VPWR VPWR sky130_fd_sc_hd__decap_3
XPHY_479 VGND VGND VPWR VPWR sky130_fd_sc_hd__decap_3
XFILLER_0_4_1185 VPWR VGND VPWR VGND sky130_ef_sc_hd__decap_12
XPHY_1078 VGND VGND VPWR VPWR sky130_fd_sc_hd__decap_3
XPHY_1067 VGND VGND VPWR VPWR sky130_fd_sc_hd__decap_3
XPHY_1089 VGND VGND VPWR VPWR sky130_fd_sc_hd__decap_3
XFILLER_0_105_921 VPWR VGND VPWR VGND sky130_ef_sc_hd__decap_12
XFILLER_0_225_1063 VGND VGND VPWR VPWR sky130_fd_sc_hd__fill_1
XFILLER_0_162_1331 VGND VGND VPWR VPWR sky130_fd_sc_hd__decap_6
XFILLER_0_105_965 VPWR VGND VPWR VGND sky130_ef_sc_hd__decap_12
XFILLER_0_0_109 VGND VGND VPWR VPWR sky130_fd_sc_hd__decap_3
XANTENNA_input52_A psum_col0_in[26] VGND VGND VPWR VPWR sky130_fd_sc_hd__diode_2
XFILLER_0_219_833 VGND VGND VPWR VPWR sky130_fd_sc_hd__decap_6
XFILLER_0_219_877 VPWR VGND VPWR VGND sky130_ef_sc_hd__decap_12
XFILLER_0_218_321 VPWR VGND VPWR VGND sky130_ef_sc_hd__decap_12
XFILLER_0_218_365 VPWR VGND VPWR VGND sky130_ef_sc_hd__decap_12
XFILLER_0_28_49 VGND VGND VPWR VPWR sky130_fd_sc_hd__fill_1
XFILLER_0_178_9 VGND VGND VPWR VPWR sky130_fd_sc_hd__fill_2
XFILLER_0_96_1281 VGND VGND VPWR VPWR sky130_fd_sc_hd__fill_1
XFILLER_0_44_15 VPWR VGND VPWR VGND sky130_ef_sc_hd__decap_12
XFILLER_0_135_39 VGND VGND VPWR VPWR sky130_fd_sc_hd__decap_8
XFILLER_0_18_1227 VPWR VGND VPWR VGND sky130_ef_sc_hd__decap_12
XFILLER_0_130_1319 VPWR VGND VPWR VGND sky130_ef_sc_hd__decap_12
XFILLER_0_72_605 VPWR VGND VPWR VGND sky130_ef_sc_hd__decap_12
XFILLER_0_151_27 VPWR VGND VPWR VGND sky130_ef_sc_hd__decap_12
XPHY_980 VGND VGND VPWR VPWR sky130_fd_sc_hd__decap_3
XPHY_991 VGND VGND VPWR VPWR sky130_fd_sc_hd__decap_3
XFILLER_0_167_1253 VGND VGND VPWR VPWR sky130_fd_sc_hd__fill_1
XFILLER_0_108_781 VPWR VGND VPWR VGND sky130_ef_sc_hd__decap_12
XFILLER_0_8_15 VPWR VGND VPWR VGND sky130_ef_sc_hd__decap_12
XFILLER_0_29_1323 VPWR VGND VPWR VGND sky130_ef_sc_hd__decap_12
XFILLER_0_107_3 VPWR VGND VPWR VGND sky130_ef_sc_hd__decap_12
XFILLER_0_64_1225 VGND VGND VPWR VPWR sky130_fd_sc_hd__fill_1
XFILLER_0_208_1283 VPWR VGND VPWR VGND sky130_ef_sc_hd__decap_12
XFILLER_0_110_401 VPWR VGND VPWR VGND sky130_ef_sc_hd__decap_12
XFILLER_0_0_643 VGND VGND VPWR VPWR sky130_fd_sc_hd__fill_1
XFILLER_0_110_445 VPWR VGND VPWR VGND sky130_ef_sc_hd__decap_12
XFILLER_0_110_489 VPWR VGND VPWR VGND sky130_ef_sc_hd__decap_12
XFILLER_0_139_1311 VPWR VGND VPWR VGND sky130_ef_sc_hd__decap_12
XFILLER_0_174_1213 VPWR VGND VPWR VGND sky130_ef_sc_hd__decap_12
XANTENNA_u_pe11_act_in[1] act_10_out_11_in\[1\] VGND VGND VPWR VPWR sky130_fd_sc_hd__diode_2
XFILLER_0_109_51 VGND VGND VPWR VPWR sky130_fd_sc_hd__decap_4
XFILLER_0_224_357 VGND VGND VPWR VPWR sky130_fd_sc_hd__decap_6
XFILLER_0_75_1343 VGND VGND VPWR VPWR sky130_fd_sc_hd__fill_1
XFILLER_0_205_593 VPWR VGND VPWR VGND sky130_ef_sc_hd__decap_12
XFILLER_0_215_1287 VGND VGND VPWR VPWR sky130_fd_sc_hd__fill_1
XFILLER_0_165_629 VPWR VGND VPWR VGND sky130_ef_sc_hd__decap_12
XFILLER_0_63_605 VPWR VGND VPWR VGND sky130_ef_sc_hd__decap_12
XFILLER_0_1_1325 VGND VGND VPWR VPWR sky130_fd_sc_hd__decap_4
XFILLER_0_185_1331 VGND VGND VPWR VPWR sky130_fd_sc_hd__fill_2
XFILLER_0_7_253 VPWR VGND VPWR VGND sky130_ef_sc_hd__decap_12
XFILLER_0_105_217 VGND VGND VPWR VPWR sky130_fd_sc_hd__decap_6
XFILLER_0_146_1337 VGND VGND VPWR VPWR sky130_fd_sc_hd__fill_1
XANTENNA_u_pe01_weight_in[8] net131 VGND VGND VPWR VPWR sky130_fd_sc_hd__diode_2
XFILLER_0_222_1203 VGND VGND VPWR VPWR sky130_fd_sc_hd__fill_1
XFILLER_0_105_1001 VGND VGND VPWR VPWR sky130_fd_sc_hd__decap_6
XFILLER_0_4_993 VPWR VGND VPWR VGND sky130_ef_sc_hd__decap_12
XFILLER_0_43_1309 VGND VGND VPWR VPWR sky130_fd_sc_hd__fill_1
XFILLER_0_113_261 VPWR VGND VPWR VGND sky130_ef_sc_hd__decap_12
XFILLER_0_105_1045 VPWR VGND VPWR VGND sky130_ef_sc_hd__decap_12
XFILLER_0_105_1089 VPWR VGND VPWR VGND sky130_ef_sc_hd__decap_12
XFILLER_0_216_825 VPWR VGND VPWR VGND sky130_ef_sc_hd__decap_12
XFILLER_0_216_869 VPWR VGND VPWR VGND sky130_ef_sc_hd__decap_12
XFILLER_0_215_335 VGND VGND VPWR VPWR sky130_fd_sc_hd__fill_1
XFILLER_0_216_1029 VGND VGND VPWR VPWR sky130_fd_sc_hd__decap_6
XFILLER_0_211_541 VPWR VGND VPWR VGND sky130_ef_sc_hd__decap_12
XFILLER_0_6_1203 VGND VGND VPWR VPWR sky130_fd_sc_hd__fill_1
XFILLER_0_211_585 VPWR VGND VPWR VGND sky130_ef_sc_hd__decap_12
XFILLER_0_112_1005 VPWR VGND VPWR VGND sky130_ef_sc_hd__decap_12
XFILLER_0_14_29 VPWR VGND VPWR VGND sky130_ef_sc_hd__decap_12
XPHY_210 VGND VGND VPWR VPWR sky130_fd_sc_hd__decap_3
XFILLER_0_112_1049 VPWR VGND VPWR VGND sky130_ef_sc_hd__decap_12
XPHY_232 VGND VGND VPWR VPWR sky130_fd_sc_hd__decap_3
XPHY_221 VGND VGND VPWR VPWR sky130_fd_sc_hd__decap_3
XFILLER_0_54_605 VPWR VGND VPWR VGND sky130_ef_sc_hd__decap_12
XPHY_243 VGND VGND VPWR VPWR sky130_fd_sc_hd__decap_3
XPHY_265 VGND VGND VPWR VPWR sky130_fd_sc_hd__decap_3
XPHY_276 VGND VGND VPWR VPWR sky130_fd_sc_hd__decap_3
XPHY_254 VGND VGND VPWR VPWR sky130_fd_sc_hd__decap_3
XPHY_287 VGND VGND VPWR VPWR sky130_fd_sc_hd__decap_3
XPHY_298 VGND VGND VPWR VPWR sky130_fd_sc_hd__decap_3
XFILLER_0_87_1225 VPWR VGND VPWR VGND sky130_ef_sc_hd__decap_12
XFILLER_0_39_15 VPWR VGND VPWR VGND sky130_ef_sc_hd__decap_12
XFILLER_0_1_429 VPWR VGND VPWR VGND sky130_ef_sc_hd__decap_12
XFILLER_0_201_1309 VGND VGND VPWR VPWR sky130_fd_sc_hd__fill_1
XFILLER_0_197_1213 VPWR VGND VPWR VGND sky130_ef_sc_hd__decap_12
XFILLER_0_219_641 VPWR VGND VPWR VGND sky130_ef_sc_hd__decap_12
XFILLER_0_63_1291 VPWR VGND VPWR VGND sky130_ef_sc_hd__decap_12
XFILLER_0_219_685 VPWR VGND VPWR VGND sky130_ef_sc_hd__decap_12
XFILLER_0_98_1343 VGND VGND VPWR VPWR sky130_fd_sc_hd__fill_1
XFILLER_0_24_1275 VGND VGND VPWR VPWR sky130_fd_sc_hd__decap_6
XFILLER_0_197_1279 VPWR VGND VPWR VGND sky130_ef_sc_hd__decap_12
XFILLER_0_218_195 VGND VGND VPWR VPWR sky130_fd_sc_hd__fill_1
XFILLER_0_146_27 VGND VGND VPWR VPWR sky130_fd_sc_hd__fill_1
XFILLER_0_221_305 VPWR VGND VPWR VGND sky130_ef_sc_hd__decap_12
XFILLER_0_55_47 VGND VGND VPWR VPWR sky130_fd_sc_hd__fill_1
XFILLER_0_146_49 VGND VGND VPWR VPWR sky130_fd_sc_hd__fill_1
XFILLER_0_221_349 VPWR VGND VPWR VGND sky130_ef_sc_hd__decap_12
XFILLER_0_162_15 VPWR VGND VPWR VGND sky130_ef_sc_hd__decap_12
XFILLER_0_134_1263 VPWR VGND VPWR VGND sky130_ef_sc_hd__decap_12
XFILLER_0_147_629 VPWR VGND VPWR VGND sky130_ef_sc_hd__decap_12
XFILLER_0_31_1213 VPWR VGND VPWR VGND sky130_ef_sc_hd__decap_12
XFILLER_0_70_1251 VPWR VGND VPWR VGND sky130_ef_sc_hd__decap_12
XFILLER_0_45_605 VPWR VGND VPWR VGND sky130_ef_sc_hd__decap_12
XFILLER_0_70_1295 VPWR VGND VPWR VGND sky130_ef_sc_hd__decap_12
XFILLER_0_210_1173 VGND VGND VPWR VPWR sky130_fd_sc_hd__decap_3
XFILLER_0_31_1279 VPWR VGND VPWR VGND sky130_ef_sc_hd__decap_12
XFILLER_0_170_643 VPWR VGND VPWR VGND sky130_ef_sc_hd__decap_12
XFILLER_0_60_619 VPWR VGND VPWR VGND sky130_ef_sc_hd__decap_12
XFILLER_0_4_245 VGND VGND VPWR VPWR sky130_fd_sc_hd__decap_6
XFILLER_0_141_1201 VPWR VGND VPWR VGND sky130_ef_sc_hd__decap_12
XFILLER_0_111_721 VGND VGND VPWR VPWR sky130_fd_sc_hd__decap_6
XFILLER_0_4_289 VPWR VGND VPWR VGND sky130_ef_sc_hd__decap_12
XFILLER_0_180_1283 VPWR VGND VPWR VGND sky130_ef_sc_hd__decap_12
XFILLER_0_111_765 VPWR VGND VPWR VGND sky130_ef_sc_hd__decap_12
XFILLER_0_141_1267 VPWR VGND VPWR VGND sky130_ef_sc_hd__decap_12
XFILLER_0_42_1331 VGND VGND VPWR VPWR sky130_fd_sc_hd__decap_6
XFILLER_0_110_253 VPWR VGND VPWR VGND sky130_ef_sc_hd__decap_12
XFILLER_0_176_1319 VPWR VGND VPWR VGND sky130_ef_sc_hd__decap_12
XFILLER_0_224_121 VPWR VGND VPWR VGND sky130_ef_sc_hd__decap_12
XTAP_2608 VGND VPWR sky130_fd_sc_hd__tapvpwrvgnd_1
XFILLER_0_213_839 VGND VGND VPWR VPWR sky130_fd_sc_hd__fill_1
XFILLER_0_224_165 VPWR VGND VPWR VGND sky130_ef_sc_hd__decap_12
XTAP_2619 VGND VPWR sky130_fd_sc_hd__tapvpwrvgnd_1
XTAP_1907 VGND VPWR sky130_fd_sc_hd__tapvpwrvgnd_1
XTAP_1929 VGND VPWR sky130_fd_sc_hd__tapvpwrvgnd_1
XTAP_1918 VGND VPWR sky130_fd_sc_hd__tapvpwrvgnd_1
XFILLER_0_113_1325 VGND VGND VPWR VPWR sky130_fd_sc_hd__decap_8
XFILLER_0_222_29 VPWR VGND VPWR VGND sky130_ef_sc_hd__decap_12
XFILLER_0_36_605 VPWR VGND VPWR VGND sky130_ef_sc_hd__decap_12
XFILLER_0_1_1133 VPWR VGND VPWR VGND sky130_ef_sc_hd__decap_12
XFILLER_0_10_1319 VPWR VGND VPWR VGND sky130_ef_sc_hd__decap_12
XFILLER_0_1_1177 VPWR VGND VPWR VGND sky130_ef_sc_hd__decap_12
XFILLER_0_224_1309 VGND VGND VPWR VPWR sky130_fd_sc_hd__decap_6
XFILLER_0_47_1253 VGND VGND VPWR VPWR sky130_fd_sc_hd__fill_1
XANTENNA_u_pe10_weight_in[10] net134 VGND VGND VPWR VPWR sky130_fd_sc_hd__diode_2
XFILLER_0_120_1307 VPWR VGND VPWR VGND sky130_ef_sc_hd__decap_12
XANTENNA_input154_A w11[14] VGND VGND VPWR VPWR sky130_fd_sc_hd__diode_2
XFILLER_0_200_1331 VGND VGND VPWR VPWR sky130_fd_sc_hd__decap_6
XFILLER_0_216_699 VGND VGND VPWR VPWR sky130_fd_sc_hd__fill_1
XFILLER_0_118_1225 VGND VGND VPWR VPWR sky130_fd_sc_hd__fill_1
XANTENNA_input15_A act_row0_in[8] VGND VGND VPWR VPWR sky130_fd_sc_hd__diode_2
XFILLER_0_19_1311 VPWR VGND VPWR VGND sky130_ef_sc_hd__decap_12
XFILLER_0_25_39 VGND VGND VPWR VPWR sky130_fd_sc_hd__decap_8
XFILLER_0_54_1213 VPWR VGND VPWR VGND sky130_ef_sc_hd__decap_12
XFILLER_0_212_861 VGND VGND VPWR VPWR sky130_fd_sc_hd__decap_6
XFILLER_0_211_393 VPWR VGND VPWR VGND sky130_ef_sc_hd__decap_12
XFILLER_0_89_1309 VGND VGND VPWR VPWR sky130_fd_sc_hd__fill_1
XFILLER_0_129_629 VPWR VGND VPWR VGND sky130_ef_sc_hd__decap_12
XFILLER_0_41_27 VPWR VGND VPWR VGND sky130_ef_sc_hd__decap_12
XFILLER_0_27_605 VPWR VGND VPWR VGND sky130_ef_sc_hd__decap_12
XFILLER_0_132_29 VPWR VGND VPWR VGND sky130_ef_sc_hd__decap_12
XFILLER_0_94_593 VPWR VGND VPWR VGND sky130_ef_sc_hd__decap_12
XFILLER_0_210_9 VGND VGND VPWR VPWR sky130_fd_sc_hd__fill_2
XFILLER_0_164_1201 VPWR VGND VPWR VGND sky130_ef_sc_hd__decap_12
XFILLER_0_42_619 VPWR VGND VPWR VGND sky130_ef_sc_hd__decap_12
XANTENNA_u_pe01_act_in[4] act_00_out_01_in\[4\] VGND VGND VPWR VPWR sky130_fd_sc_hd__diode_2
XFILLER_0_129_1343 VGND VGND VPWR VPWR sky130_fd_sc_hd__fill_1
XFILLER_0_152_643 VPWR VGND VPWR VGND sky130_ef_sc_hd__decap_12
XFILLER_0_2_749 VGND VGND VPWR VPWR sky130_fd_sc_hd__decap_6
XFILLER_0_205_1253 VGND VGND VPWR VPWR sky130_fd_sc_hd__fill_1
XFILLER_0_1_237 VPWR VGND VPWR VGND sky130_ef_sc_hd__decap_12
XFILLER_0_26_1337 VGND VGND VPWR VPWR sky130_fd_sc_hd__fill_1
XFILLER_0_5_27 VPWR VGND VPWR VGND sky130_ef_sc_hd__decap_12
XFILLER_0_174_3 VPWR VGND VPWR VGND sky130_ef_sc_hd__decap_12
XFILLER_0_222_625 VPWR VGND VPWR VGND sky130_ef_sc_hd__decap_12
XFILLER_0_221_113 VPWR VGND VPWR VGND sky130_ef_sc_hd__decap_12
XFILLER_0_222_669 VPWR VGND VPWR VGND sky130_ef_sc_hd__decap_12
XFILLER_0_210_809 VGND VGND VPWR VPWR sky130_fd_sc_hd__decap_3
XFILLER_0_173_47 VGND VGND VPWR VPWR sky130_fd_sc_hd__fill_1
XFILLER_0_171_1249 VGND VGND VPWR VPWR sky130_fd_sc_hd__decap_4
XFILLER_0_106_41 VPWR VGND VPWR VGND sky130_ef_sc_hd__decap_12
XFILLER_0_106_85 VPWR VGND VPWR VGND sky130_ef_sc_hd__decap_12
XFILLER_0_18_605 VPWR VGND VPWR VGND sky130_ef_sc_hd__decap_12
XFILLER_0_85_593 VPWR VGND VPWR VGND sky130_ef_sc_hd__decap_12
XFILLER_0_79_3 VPWR VGND VPWR VGND sky130_ef_sc_hd__decap_12
XFILLER_0_41_641 VGND VGND VPWR VPWR sky130_fd_sc_hd__decap_4
XFILLER_0_111_573 VPWR VGND VPWR VGND sky130_ef_sc_hd__decap_12
XFILLER_0_106_1173 VPWR VGND VPWR VGND sky130_ef_sc_hd__decap_12
XFILLER_0_0_281 VGND VGND VPWR VPWR sky130_fd_sc_hd__decap_8
XFILLER_0_226_920 VGND VGND VPWR VPWR sky130_fd_sc_hd__decap_4
XANTENNA_input7_A act_row0_in[15] VGND VGND VPWR VPWR sky130_fd_sc_hd__diode_2
XFILLER_0_226_953 VPWR VGND VPWR VGND sky130_ef_sc_hd__decap_12
XFILLER_0_225_441 VGND VGND VPWR VPWR sky130_fd_sc_hd__decap_6
XFILLER_0_77_1213 VPWR VGND VPWR VGND sky130_ef_sc_hd__decap_12
XFILLER_0_217_1113 VGND VGND VPWR VPWR sky130_fd_sc_hd__decap_6
XFILLER_0_225_485 VPWR VGND VPWR VGND sky130_ef_sc_hd__decap_12
XFILLER_0_77_1279 VPWR VGND VPWR VGND sky130_ef_sc_hd__decap_12
XFILLER_0_217_1157 VPWR VGND VPWR VGND sky130_ef_sc_hd__decap_12
XTAP_2427 VGND VPWR sky130_fd_sc_hd__tapvpwrvgnd_1
XTAP_2416 VGND VPWR sky130_fd_sc_hd__tapvpwrvgnd_1
XTAP_2405 VGND VPWR sky130_fd_sc_hd__tapvpwrvgnd_1
XTAP_2438 VGND VPWR sky130_fd_sc_hd__tapvpwrvgnd_1
XTAP_2449 VGND VPWR sky130_fd_sc_hd__tapvpwrvgnd_1
XTAP_1704 VGND VPWR sky130_fd_sc_hd__tapvpwrvgnd_1
XTAP_1715 VGND VPWR sky130_fd_sc_hd__tapvpwrvgnd_1
XFILLER_0_117_1291 VPWR VGND VPWR VGND sky130_ef_sc_hd__decap_12
XTAP_1726 VGND VPWR sky130_fd_sc_hd__tapvpwrvgnd_1
XTAP_1737 VGND VPWR sky130_fd_sc_hd__tapvpwrvgnd_1
XTAP_1748 VGND VPWR sky130_fd_sc_hd__tapvpwrvgnd_1
XFILLER_0_187_1201 VPWR VGND VPWR VGND sky130_ef_sc_hd__decap_12
XFILLER_0_113_1133 VPWR VGND VPWR VGND sky130_ef_sc_hd__decap_12
XTAP_1759 VGND VPWR sky130_fd_sc_hd__tapvpwrvgnd_1
XFILLER_0_113_1177 VPWR VGND VPWR VGND sky130_ef_sc_hd__decap_12
XFILLER_0_88_1331 VGND VGND VPWR VPWR sky130_fd_sc_hd__decap_6
XFILLER_0_76_593 VPWR VGND VPWR VGND sky130_ef_sc_hd__decap_12
XFILLER_0_14_1263 VPWR VGND VPWR VGND sky130_ef_sc_hd__decap_12
XFILLER_0_187_1267 VPWR VGND VPWR VGND sky130_ef_sc_hd__decap_12
XFILLER_0_24_619 VPWR VGND VPWR VGND sky130_ef_sc_hd__decap_12
XFILLER_0_106_301 VGND VGND VPWR VPWR sky130_fd_sc_hd__decap_6
XFILLER_0_134_643 VPWR VGND VPWR VGND sky130_ef_sc_hd__decap_12
XFILLER_0_84_1239 VPWR VGND VPWR VGND sky130_ef_sc_hd__decap_12
XFILLER_0_106_345 VPWR VGND VPWR VGND sky130_ef_sc_hd__decap_12
XFILLER_0_224_1117 VPWR VGND VPWR VGND sky130_ef_sc_hd__decap_12
XFILLER_0_106_389 VPWR VGND VPWR VGND sky130_ef_sc_hd__decap_12
XFILLER_0_124_1251 VPWR VGND VPWR VGND sky130_ef_sc_hd__decap_12
XFILLER_0_159_1303 VGND VGND VPWR VPWR sky130_fd_sc_hd__decap_6
XFILLER_0_124_1295 VPWR VGND VPWR VGND sky130_ef_sc_hd__decap_12
XFILLER_0_21_1201 VPWR VGND VPWR VGND sky130_ef_sc_hd__decap_12
XFILLER_0_60_1283 VPWR VGND VPWR VGND sky130_ef_sc_hd__decap_12
XFILLER_0_194_1227 VPWR VGND VPWR VGND sky130_ef_sc_hd__decap_12
XFILLER_0_217_953 VPWR VGND VPWR VGND sky130_ef_sc_hd__decap_12
XFILLER_0_95_1335 VGND VGND VPWR VPWR sky130_fd_sc_hd__fill_1
XFILLER_0_36_27 VGND VGND VPWR VPWR sky130_fd_sc_hd__fill_1
XFILLER_0_21_1267 VPWR VGND VPWR VGND sky130_ef_sc_hd__decap_12
XFILLER_0_36_49 VGND VGND VPWR VPWR sky130_fd_sc_hd__fill_1
XFILLER_0_56_1319 VPWR VGND VPWR VGND sky130_ef_sc_hd__decap_12
XFILLER_0_99_641 VGND VGND VPWR VPWR sky130_fd_sc_hd__decap_4
XTAP_2961 VGND VPWR sky130_fd_sc_hd__tapvpwrvgnd_1
XTAP_2950 VGND VPWR sky130_fd_sc_hd__tapvpwrvgnd_1
XFILLER_0_131_1255 VPWR VGND VPWR VGND sky130_ef_sc_hd__decap_12
XFILLER_0_6_307 VGND VGND VPWR VPWR sky130_fd_sc_hd__fill_1
XFILLER_0_67_593 VPWR VGND VPWR VGND sky130_ef_sc_hd__decap_12
XFILLER_0_166_1307 VPWR VGND VPWR VGND sky130_ef_sc_hd__decap_12
XFILLER_0_109_161 VGND VGND VPWR VPWR sky130_fd_sc_hd__decap_6
XFILLER_0_2_513 VPWR VGND VPWR VGND sky130_ef_sc_hd__decap_12
XFILLER_0_23_641 VGND VGND VPWR VPWR sky130_fd_sc_hd__decap_4
XFILLER_0_2_557 VPWR VGND VPWR VGND sky130_ef_sc_hd__decap_12
XFILLER_0_77_34 VPWR VGND VPWR VGND sky130_ef_sc_hd__decap_12
XFILLER_0_103_1335 VGND VGND VPWR VPWR sky130_fd_sc_hd__decap_8
XFILLER_0_226_216 VGND VGND VPWR VPWR sky130_fd_sc_hd__decap_8
XFILLER_0_223_945 VGND VGND VPWR VPWR sky130_fd_sc_hd__decap_6
XFILLER_0_222_433 VPWR VGND VPWR VGND sky130_ef_sc_hd__decap_12
XFILLER_0_223_989 VPWR VGND VPWR VGND sky130_ef_sc_hd__decap_12
XFILLER_0_210_617 VPWR VGND VPWR VGND sky130_ef_sc_hd__decap_12
XFILLER_0_222_477 VPWR VGND VPWR VGND sky130_ef_sc_hd__decap_12
XPHY_809 VGND VGND VPWR VPWR sky130_fd_sc_hd__decap_3
XFILLER_0_110_1317 VPWR VGND VPWR VGND sky130_ef_sc_hd__decap_12
XFILLER_0_58_593 VPWR VGND VPWR VGND sky130_ef_sc_hd__decap_12
XFILLER_0_116_643 VPWR VGND VPWR VGND sky130_ef_sc_hd__decap_12
XFILLER_0_2_1261 VPWR VGND VPWR VGND sky130_ef_sc_hd__decap_12
XFILLER_0_5_373 VPWR VGND VPWR VGND sky130_ef_sc_hd__decap_12
XFILLER_0_44_1201 VPWR VGND VPWR VGND sky130_ef_sc_hd__decap_12
XFILLER_0_112_893 VPWR VGND VPWR VGND sky130_ef_sc_hd__decap_12
XFILLER_0_217_205 VPWR VGND VPWR VGND sky130_ef_sc_hd__decap_12
XFILLER_0_217_249 VPWR VGND VPWR VGND sky130_ef_sc_hd__decap_12
XFILLER_0_214_923 VGND VGND VPWR VPWR sky130_fd_sc_hd__fill_1
XFILLER_0_225_293 VPWR VGND VPWR VGND sky130_ef_sc_hd__decap_12
XFILLER_0_201_617 VPWR VGND VPWR VGND sky130_ef_sc_hd__decap_12
XTAP_2235 VGND VPWR sky130_fd_sc_hd__tapvpwrvgnd_1
XTAP_2224 VGND VPWR sky130_fd_sc_hd__tapvpwrvgnd_1
XTAP_2213 VGND VPWR sky130_fd_sc_hd__tapvpwrvgnd_1
XTAP_2202 VGND VPWR sky130_fd_sc_hd__tapvpwrvgnd_1
XTAP_2268 VGND VPWR sky130_fd_sc_hd__tapvpwrvgnd_1
XTAP_2246 VGND VPWR sky130_fd_sc_hd__tapvpwrvgnd_1
XFILLER_0_96_655 VGND VGND VPWR VPWR sky130_fd_sc_hd__decap_4
XTAP_1501 VGND VPWR sky130_fd_sc_hd__tapvpwrvgnd_1
XPHY_30 VGND VGND VPWR VPWR sky130_fd_sc_hd__decap_3
XTAP_1512 VGND VPWR sky130_fd_sc_hd__tapvpwrvgnd_1
XTAP_1523 VGND VPWR sky130_fd_sc_hd__tapvpwrvgnd_1
XANTENNA_input117_A w01[0] VGND VGND VPWR VPWR sky130_fd_sc_hd__diode_2
XTAP_2257 VGND VPWR sky130_fd_sc_hd__tapvpwrvgnd_1
XTAP_2279 VGND VPWR sky130_fd_sc_hd__tapvpwrvgnd_1
XPHY_52 VGND VGND VPWR VPWR sky130_fd_sc_hd__decap_3
XPHY_41 VGND VGND VPWR VPWR sky130_fd_sc_hd__decap_3
XTAP_1534 VGND VPWR sky130_fd_sc_hd__tapvpwrvgnd_1
XFILLER_0_7_1161 VPWR VGND VPWR VGND sky130_ef_sc_hd__decap_12
XPHY_63 VGND VGND VPWR VPWR sky130_fd_sc_hd__decap_3
XPHY_74 VGND VGND VPWR VPWR sky130_fd_sc_hd__decap_3
XTAP_1545 VGND VPWR sky130_fd_sc_hd__tapvpwrvgnd_1
XTAP_1556 VGND VPWR sky130_fd_sc_hd__tapvpwrvgnd_1
XTAP_1567 VGND VPWR sky130_fd_sc_hd__tapvpwrvgnd_1
XFILLER_0_51_1249 VGND VGND VPWR VPWR sky130_fd_sc_hd__decap_4
XTAP_1589 VGND VPWR sky130_fd_sc_hd__tapvpwrvgnd_1
XFILLER_0_22_29 VPWR VGND VPWR VGND sky130_ef_sc_hd__decap_12
XPHY_85 VGND VGND VPWR VPWR sky130_fd_sc_hd__decap_3
XPHY_96 VGND VGND VPWR VPWR sky130_fd_sc_hd__decap_3
XTAP_1578 VGND VPWR sky130_fd_sc_hd__tapvpwrvgnd_1
XFILLER_0_49_593 VPWR VGND VPWR VGND sky130_ef_sc_hd__decap_12
XANTENNA_input82_A psum_col1_in[24] VGND VGND VPWR VPWR sky130_fd_sc_hd__diode_2
XFILLER_0_107_665 VGND VGND VPWR VPWR sky130_fd_sc_hd__decap_6
XFILLER_0_106_153 VPWR VGND VPWR VGND sky130_ef_sc_hd__decap_12
XFILLER_0_106_197 VPWR VGND VPWR VGND sky130_ef_sc_hd__decap_12
XFILLER_0_202_1201 VPWR VGND VPWR VGND sky130_ef_sc_hd__decap_12
XFILLER_0_161_1237 VPWR VGND VPWR VGND sky130_ef_sc_hd__decap_12
XFILLER_0_20_655 VGND VGND VPWR VPWR sky130_fd_sc_hd__decap_4
XFILLER_0_47_15 VPWR VGND VPWR VGND sky130_ef_sc_hd__decap_12
XFILLER_0_217_783 VGND VGND VPWR VPWR sky130_fd_sc_hd__fill_1
XFILLER_0_218_83 VGND VGND VPWR VPWR sky130_fd_sc_hd__fill_1
XFILLER_0_154_49 VGND VGND VPWR VPWR sky130_fd_sc_hd__fill_1
XFILLER_0_220_937 VPWR VGND VPWR VGND sky130_ef_sc_hd__decap_12
XTAP_2791 VGND VPWR sky130_fd_sc_hd__tapvpwrvgnd_1
XTAP_2780 VGND VPWR sky130_fd_sc_hd__tapvpwrvgnd_1
XFILLER_0_170_15 VPWR VGND VPWR VGND sky130_ef_sc_hd__decap_12
XFILLER_0_137_3 VPWR VGND VPWR VGND sky130_ef_sc_hd__decap_12
XFILLER_0_67_1201 VPWR VGND VPWR VGND sky130_ef_sc_hd__decap_12
XFILLER_0_3_833 VGND VGND VPWR VPWR sky130_fd_sc_hd__decap_6
XFILLER_0_2_321 VPWR VGND VPWR VGND sky130_ef_sc_hd__decap_12
XFILLER_0_67_1267 VPWR VGND VPWR VGND sky130_ef_sc_hd__decap_12
XFILLER_0_3_877 VPWR VGND VPWR VGND sky130_ef_sc_hd__decap_12
XFILLER_0_2_365 VPWR VGND VPWR VGND sky130_ef_sc_hd__decap_12
XFILLER_0_63_6 VGND VGND VPWR VPWR sky130_fd_sc_hd__fill_2
Xoutput168 net168 VGND VGND VPWR VPWR psum_col0_out[12] sky130_fd_sc_hd__clkbuf_4
XFILLER_0_112_189 VGND VGND VPWR VPWR sky130_fd_sc_hd__decap_6
Xoutput179 net179 VGND VGND VPWR VPWR psum_col0_out[22] sky130_fd_sc_hd__clkbuf_4
XFILLER_0_215_709 VPWR VGND VPWR VGND sky130_ef_sc_hd__decap_12
XFILLER_0_177_1255 VPWR VGND VPWR VGND sky130_ef_sc_hd__decap_12
XFILLER_0_39_1303 VGND VGND VPWR VPWR sky130_fd_sc_hd__decap_6
XFILLER_0_218_1241 VPWR VGND VPWR VGND sky130_ef_sc_hd__decap_12
XFILLER_0_138_1239 VPWR VGND VPWR VGND sky130_ef_sc_hd__decap_12
XFILLER_0_218_1285 VPWR VGND VPWR VGND sky130_ef_sc_hd__decap_12
XFILLER_0_214_1105 VPWR VGND VPWR VGND sky130_ef_sc_hd__decap_12
XFILLER_0_223_753 VPWR VGND VPWR VGND sky130_ef_sc_hd__decap_12
XFILLER_0_74_1227 VPWR VGND VPWR VGND sky130_ef_sc_hd__decap_12
XFILLER_0_214_1149 VPWR VGND VPWR VGND sky130_ef_sc_hd__decap_12
XFILLER_0_223_797 VPWR VGND VPWR VGND sky130_ef_sc_hd__decap_12
XFILLER_0_195_605 VPWR VGND VPWR VGND sky130_ef_sc_hd__decap_12
XFILLER_0_78_655 VGND VGND VPWR VPWR sky130_fd_sc_hd__decap_4
XPHY_617 VGND VGND VPWR VPWR sky130_fd_sc_hd__decap_3
XPHY_606 VGND VGND VPWR VPWR sky130_fd_sc_hd__decap_3
XPHY_1205 VGND VGND VPWR VPWR sky130_fd_sc_hd__decap_3
XFILLER_0_114_1261 VPWR VGND VPWR VGND sky130_ef_sc_hd__decap_12
XPHY_628 VGND VGND VPWR VPWR sky130_fd_sc_hd__decap_3
XFILLER_0_93_647 VPWR VGND VPWR VGND sky130_ef_sc_hd__decap_12
XPHY_639 VGND VGND VPWR VPWR sky130_fd_sc_hd__decap_3
XPHY_1216 VGND VGND VPWR VPWR sky130_fd_sc_hd__decap_3
XFILLER_0_110_1147 VGND VGND VPWR VPWR sky130_fd_sc_hd__fill_1
XFILLER_0_149_1335 VGND VGND VPWR VPWR sky130_fd_sc_hd__fill_1
XFILLER_0_11_1255 VPWR VGND VPWR VGND sky130_ef_sc_hd__decap_12
XFILLER_0_225_1201 VPWR VGND VPWR VGND sky130_ef_sc_hd__decap_12
XFILLER_0_104_613 VGND VGND VPWR VPWR sky130_fd_sc_hd__decap_3
XFILLER_0_2_1091 VGND VGND VPWR VPWR sky130_fd_sc_hd__fill_1
XFILLER_0_85_1323 VPWR VGND VPWR VGND sky130_ef_sc_hd__decap_12
XFILLER_0_225_1245 VPWR VGND VPWR VGND sky130_ef_sc_hd__decap_12
XFILLER_0_5_181 VPWR VGND VPWR VGND sky130_ef_sc_hd__decap_12
XFILLER_0_6_693 VGND VGND VPWR VPWR sky130_fd_sc_hd__decap_6
XFILLER_0_46_1307 VPWR VGND VPWR VGND sky130_ef_sc_hd__decap_12
XFILLER_0_104_657 VPWR VGND VPWR VGND sky130_ef_sc_hd__decap_12
XFILLER_0_225_1289 VPWR VGND VPWR VGND sky130_ef_sc_hd__decap_12
XFILLER_0_218_525 VGND VGND VPWR VPWR sky130_fd_sc_hd__decap_6
XFILLER_0_160_1281 VGND VGND VPWR VPWR sky130_fd_sc_hd__fill_1
XFILLER_0_195_1311 VPWR VGND VPWR VGND sky130_ef_sc_hd__decap_12
XFILLER_0_218_569 VPWR VGND VPWR VGND sky130_ef_sc_hd__decap_12
XFILLER_0_156_1339 VGND VGND VPWR VPWR sky130_fd_sc_hd__decap_4
XTAP_2010 VGND VPWR sky130_fd_sc_hd__tapvpwrvgnd_1
XFILLER_0_9_1201 VPWR VGND VPWR VGND sky130_ef_sc_hd__decap_12
XFILLER_0_186_605 VPWR VGND VPWR VGND sky130_ef_sc_hd__decap_12
XTAP_2021 VGND VPWR sky130_fd_sc_hd__tapvpwrvgnd_1
XTAP_2043 VGND VPWR sky130_fd_sc_hd__tapvpwrvgnd_1
XFILLER_0_69_655 VGND VGND VPWR VPWR sky130_fd_sc_hd__fill_2
XTAP_2032 VGND VPWR sky130_fd_sc_hd__tapvpwrvgnd_1
XTAP_2065 VGND VPWR sky130_fd_sc_hd__tapvpwrvgnd_1
XTAP_1320 VGND VPWR sky130_fd_sc_hd__tapvpwrvgnd_1
XFILLER_0_33_39 VGND VGND VPWR VPWR sky130_fd_sc_hd__decap_8
XTAP_1331 VGND VPWR sky130_fd_sc_hd__tapvpwrvgnd_1
XFILLER_0_9_1267 VPWR VGND VPWR VGND sky130_ef_sc_hd__decap_12
XTAP_2076 VGND VPWR sky130_fd_sc_hd__tapvpwrvgnd_1
XTAP_2054 VGND VPWR sky130_fd_sc_hd__tapvpwrvgnd_1
XFILLER_0_210_981 VGND VGND VPWR VPWR sky130_fd_sc_hd__fill_2
XFILLER_0_210_970 VGND VGND VPWR VPWR sky130_fd_sc_hd__decap_8
XFILLER_0_204_41 VGND VGND VPWR VPWR sky130_fd_sc_hd__decap_8
XTAP_2087 VGND VPWR sky130_fd_sc_hd__tapvpwrvgnd_1
XTAP_1364 VGND VPWR sky130_fd_sc_hd__tapvpwrvgnd_1
XTAP_1342 VGND VPWR sky130_fd_sc_hd__tapvpwrvgnd_1
XTAP_1375 VGND VPWR sky130_fd_sc_hd__tapvpwrvgnd_1
XTAP_1353 VGND VPWR sky130_fd_sc_hd__tapvpwrvgnd_1
XTAP_2098 VGND VPWR sky130_fd_sc_hd__tapvpwrvgnd_1
XTAP_1386 VGND VPWR sky130_fd_sc_hd__tapvpwrvgnd_1
XTAP_1397 VGND VPWR sky130_fd_sc_hd__tapvpwrvgnd_1
XFILLER_0_140_29 VPWR VGND VPWR VGND sky130_ef_sc_hd__decap_12
XFILLER_0_226_1009 VGND VGND VPWR VPWR sky130_fd_sc_hd__decap_4
Xinput37 psum_col0_in[12] VGND VGND VPWR VPWR net37 sky130_fd_sc_hd__buf_1
Xinput26 act_row1_in[3] VGND VGND VPWR VPWR net26 sky130_fd_sc_hd__buf_1
Xinput15 act_row0_in[8] VGND VGND VPWR VPWR net15 sky130_fd_sc_hd__clkbuf_4
XFILLER_0_107_473 VPWR VGND VPWR VGND sky130_ef_sc_hd__decap_12
Xinput48 psum_col0_in[22] VGND VGND VPWR VPWR net48 sky130_fd_sc_hd__buf_1
Xinput59 psum_col0_in[3] VGND VGND VPWR VPWR net59 sky130_fd_sc_hd__buf_1
XFILLER_0_204_1307 VPWR VGND VPWR VGND sky130_ef_sc_hd__decap_12
XFILLER_0_0_847 VPWR VGND VPWR VGND sky130_ef_sc_hd__decap_12
XFILLER_0_149_27 VPWR VGND VPWR VGND sky130_ef_sc_hd__decap_12
XFILLER_0_0_869 VPWR VGND VPWR VGND sky130_ef_sc_hd__decap_12
XFILLER_0_97_1249 VGND VGND VPWR VPWR sky130_fd_sc_hd__decap_4
XFILLER_0_165_15 VPWR VGND VPWR VGND sky130_ef_sc_hd__decap_12
XFILLER_0_220_701 VPWR VGND VPWR VGND sky130_ef_sc_hd__decap_12
XFILLER_0_28_9 VGND VGND VPWR VPWR sky130_fd_sc_hd__fill_2
XFILLER_0_177_605 VPWR VGND VPWR VGND sky130_ef_sc_hd__decap_12
XFILLER_0_181_47 VGND VGND VPWR VPWR sky130_fd_sc_hd__fill_1
XFILLER_0_192_619 VPWR VGND VPWR VGND sky130_ef_sc_hd__decap_12
XFILLER_0_75_647 VGND VGND VPWR VPWR sky130_fd_sc_hd__decap_8
XFILLER_0_114_41 VPWR VGND VPWR VGND sky130_ef_sc_hd__decap_12
XFILLER_0_114_85 VPWR VGND VPWR VGND sky130_ef_sc_hd__decap_12
XFILLER_0_90_617 VGND VGND VPWR VPWR sky130_fd_sc_hd__fill_1
XFILLER_0_114_977 VGND VGND VPWR VPWR sky130_fd_sc_hd__decap_3
XFILLER_0_101_605 VPWR VGND VPWR VGND sky130_ef_sc_hd__decap_12
XFILLER_0_3_641 VPWR VGND VPWR VGND sky130_ef_sc_hd__decap_12
XFILLER_0_3_685 VPWR VGND VPWR VGND sky130_ef_sc_hd__decap_12
XFILLER_0_61_3 VPWR VGND VPWR VGND sky130_ef_sc_hd__decap_12
XFILLER_0_2_195 VGND VGND VPWR VPWR sky130_fd_sc_hd__fill_1
XFILLER_0_41_1237 VPWR VGND VPWR VGND sky130_ef_sc_hd__decap_12
XFILLER_0_80_1275 VGND VGND VPWR VPWR sky130_fd_sc_hd__decap_6
XFILLER_0_220_1197 VGND VGND VPWR VPWR sky130_fd_sc_hd__decap_6
XFILLER_0_215_517 VPWR VGND VPWR VGND sky130_ef_sc_hd__decap_12
XFILLER_0_223_561 VPWR VGND VPWR VGND sky130_ef_sc_hd__decap_12
XFILLER_0_218_1093 VPWR VGND VPWR VGND sky130_ef_sc_hd__decap_12
XFILLER_0_190_1263 VPWR VGND VPWR VGND sky130_ef_sc_hd__decap_12
XFILLER_0_168_605 VPWR VGND VPWR VGND sky130_ef_sc_hd__decap_12
XFILLER_0_3_93 VPWR VGND VPWR VGND sky130_ef_sc_hd__decap_12
XFILLER_0_151_1225 VPWR VGND VPWR VGND sky130_ef_sc_hd__decap_12
XFILLER_0_210_277 VGND VGND VPWR VPWR sky130_fd_sc_hd__decap_3
XPHY_425 VGND VGND VPWR VPWR sky130_fd_sc_hd__decap_3
XPHY_403 VGND VGND VPWR VPWR sky130_fd_sc_hd__decap_3
XPHY_414 VGND VGND VPWR VPWR sky130_fd_sc_hd__decap_3
XPHY_1002 VGND VGND VPWR VPWR sky130_fd_sc_hd__decap_3
XPHY_1013 VGND VGND VPWR VPWR sky130_fd_sc_hd__decap_3
XFILLER_0_109_727 VGND VGND VPWR VPWR sky130_fd_sc_hd__fill_1
XPHY_436 VGND VGND VPWR VPWR sky130_fd_sc_hd__decap_3
XPHY_447 VGND VGND VPWR VPWR sky130_fd_sc_hd__decap_3
XPHY_458 VGND VGND VPWR VPWR sky130_fd_sc_hd__decap_3
XFILLER_0_191_641 VGND VGND VPWR VPWR sky130_fd_sc_hd__decap_4
XPHY_1024 VGND VGND VPWR VPWR sky130_fd_sc_hd__decap_3
XPHY_1046 VGND VGND VPWR VPWR sky130_fd_sc_hd__decap_3
XPHY_1035 VGND VGND VPWR VPWR sky130_fd_sc_hd__decap_3
XFILLER_0_81_617 VPWR VGND VPWR VGND sky130_ef_sc_hd__decap_12
XPHY_469 VGND VGND VPWR VPWR sky130_fd_sc_hd__decap_3
XPHY_1068 VGND VGND VPWR VPWR sky130_fd_sc_hd__decap_3
XPHY_1057 VGND VGND VPWR VPWR sky130_fd_sc_hd__decap_3
XPHY_1079 VGND VGND VPWR VPWR sky130_fd_sc_hd__decap_3
XFILLER_0_4_1197 VGND VGND VPWR VPWR sky130_fd_sc_hd__decap_6
XFILLER_0_105_933 VPWR VGND VPWR VGND sky130_ef_sc_hd__decap_12
XFILLER_0_104_421 VPWR VGND VPWR VGND sky130_ef_sc_hd__decap_12
XFILLER_0_162_1343 VGND VGND VPWR VPWR sky130_fd_sc_hd__fill_1
XFILLER_0_105_977 VPWR VGND VPWR VGND sky130_ef_sc_hd__decap_12
XANTENNA_input45_A psum_col0_in[1] VGND VGND VPWR VPWR sky130_fd_sc_hd__diode_2
XFILLER_0_218_333 VPWR VGND VPWR VGND sky130_ef_sc_hd__decap_12
XFILLER_0_219_889 VGND VGND VPWR VPWR sky130_fd_sc_hd__decap_6
XFILLER_0_218_377 VPWR VGND VPWR VGND sky130_ef_sc_hd__decap_12
XFILLER_0_159_605 VPWR VGND VPWR VGND sky130_ef_sc_hd__decap_12
XFILLER_0_44_49 VGND VGND VPWR VPWR sky130_fd_sc_hd__fill_1
XFILLER_0_44_27 VGND VGND VPWR VPWR sky130_fd_sc_hd__fill_1
XFILLER_0_57_1255 VPWR VGND VPWR VGND sky130_ef_sc_hd__decap_12
XFILLER_0_215_51 VGND VGND VPWR VPWR sky130_fd_sc_hd__decap_4
XFILLER_0_18_1239 VPWR VGND VPWR VGND sky130_ef_sc_hd__decap_12
XFILLER_0_174_619 VPWR VGND VPWR VGND sky130_ef_sc_hd__decap_12
XFILLER_0_60_15 VPWR VGND VPWR VGND sky130_ef_sc_hd__decap_12
XFILLER_0_57_647 VGND VGND VPWR VPWR sky130_fd_sc_hd__decap_8
XFILLER_0_151_39 VGND VGND VPWR VPWR sky130_fd_sc_hd__decap_8
XPHY_981 VGND VGND VPWR VPWR sky130_fd_sc_hd__decap_3
XPHY_970 VGND VGND VPWR VPWR sky130_fd_sc_hd__decap_3
XFILLER_0_72_617 VGND VGND VPWR VPWR sky130_fd_sc_hd__fill_1
XPHY_992 VGND VGND VPWR VPWR sky130_fd_sc_hd__decap_3
XFILLER_0_128_1227 VPWR VGND VPWR VGND sky130_ef_sc_hd__decap_12
XFILLER_0_108_793 VPWR VGND VPWR VGND sky130_ef_sc_hd__decap_12
XFILLER_0_8_27 VGND VGND VPWR VPWR sky130_fd_sc_hd__fill_1
XFILLER_0_107_281 VPWR VGND VPWR VGND sky130_ef_sc_hd__decap_12
XFILLER_0_208_1251 VPWR VGND VPWR VGND sky130_ef_sc_hd__decap_12
XFILLER_0_8_49 VGND VGND VPWR VPWR sky130_fd_sc_hd__fill_1
XFILLER_0_29_1335 VGND VGND VPWR VPWR sky130_fd_sc_hd__fill_1
XFILLER_0_208_1295 VPWR VGND VPWR VGND sky130_ef_sc_hd__decap_12
XFILLER_0_110_413 VGND VGND VPWR VPWR sky130_fd_sc_hd__decap_6
XFILLER_0_150_593 VPWR VGND VPWR VGND sky130_ef_sc_hd__decap_12
XFILLER_0_110_457 VPWR VGND VPWR VGND sky130_ef_sc_hd__decap_12
XFILLER_0_0_699 VGND VGND VPWR VPWR sky130_fd_sc_hd__fill_1
XFILLER_0_174_1225 VGND VGND VPWR VPWR sky130_fd_sc_hd__fill_1
XFILLER_0_139_1323 VPWR VGND VPWR VGND sky130_ef_sc_hd__decap_12
XANTENNA_u_pe11_act_in[0] act_10_out_11_in\[0\] VGND VGND VPWR VPWR sky130_fd_sc_hd__diode_2
XFILLER_0_40_1281 VGND VGND VPWR VPWR sky130_fd_sc_hd__fill_1
XFILLER_0_192_13 VPWR VGND VPWR VGND sky130_ef_sc_hd__decap_12
XFILLER_0_75_1311 VPWR VGND VPWR VGND sky130_ef_sc_hd__decap_12
XFILLER_0_215_1233 VPWR VGND VPWR VGND sky130_ef_sc_hd__decap_12
XFILLER_0_220_531 VGND VGND VPWR VPWR sky130_fd_sc_hd__fill_1
XFILLER_0_36_1339 VGND VGND VPWR VPWR sky130_fd_sc_hd__decap_4
XFILLER_0_211_1119 VGND VGND VPWR VPWR sky130_fd_sc_hd__fill_1
XFILLER_0_111_1231 VGND VGND VPWR VPWR sky130_fd_sc_hd__fill_1
XFILLER_0_173_641 VGND VGND VPWR VPWR sky130_fd_sc_hd__decap_4
XFILLER_0_7_221 VGND VGND VPWR VPWR sky130_fd_sc_hd__decap_3
XFILLER_0_63_617 VPWR VGND VPWR VGND sky130_ef_sc_hd__decap_12
XFILLER_0_7_265 VPWR VGND VPWR VGND sky130_ef_sc_hd__decap_12
XANTENNA_u_pe01_weight_in[7] net130 VGND VGND VPWR VPWR sky130_fd_sc_hd__diode_2
XFILLER_0_114_741 VPWR VGND VPWR VGND sky130_ef_sc_hd__decap_12
XFILLER_0_4_961 VPWR VGND VPWR VGND sky130_ef_sc_hd__decap_12
XFILLER_0_82_1337 VGND VGND VPWR VPWR sky130_fd_sc_hd__fill_1
XFILLER_0_114_785 VPWR VGND VPWR VGND sky130_ef_sc_hd__decap_12
XFILLER_0_113_273 VGND VGND VPWR VPWR sky130_fd_sc_hd__decap_6
XFILLER_0_222_1259 VGND VGND VPWR VPWR sky130_fd_sc_hd__fill_1
XFILLER_0_141_593 VPWR VGND VPWR VGND sky130_ef_sc_hd__decap_12
XFILLER_0_105_1057 VGND VGND VPWR VPWR sky130_fd_sc_hd__decap_6
XFILLER_0_216_837 VPWR VGND VPWR VGND sky130_ef_sc_hd__decap_12
XFILLER_0_224_881 VPWR VGND VPWR VGND sky130_ef_sc_hd__decap_12
XFILLER_0_153_1309 VGND VGND VPWR VPWR sky130_fd_sc_hd__fill_1
XFILLER_0_223_391 VGND VGND VPWR VPWR sky130_fd_sc_hd__fill_1
XFILLER_0_211_553 VGND VGND VPWR VPWR sky130_fd_sc_hd__decap_6
XFILLER_0_156_619 VPWR VGND VPWR VGND sky130_ef_sc_hd__decap_12
XPHY_200 VGND VGND VPWR VPWR sky130_fd_sc_hd__decap_3
XFILLER_0_211_597 VPWR VGND VPWR VGND sky130_ef_sc_hd__decap_12
XFILLER_0_112_1017 VPWR VGND VPWR VGND sky130_ef_sc_hd__decap_12
XPHY_233 VGND VGND VPWR VPWR sky130_fd_sc_hd__decap_3
XFILLER_0_39_647 VGND VGND VPWR VPWR sky130_fd_sc_hd__decap_8
XPHY_211 VGND VGND VPWR VPWR sky130_fd_sc_hd__decap_3
XPHY_222 VGND VGND VPWR VPWR sky130_fd_sc_hd__decap_3
XFILLER_0_6_1259 VGND VGND VPWR VPWR sky130_fd_sc_hd__fill_1
XPHY_244 VGND VGND VPWR VPWR sky130_fd_sc_hd__decap_3
XPHY_277 VGND VGND VPWR VPWR sky130_fd_sc_hd__decap_3
XFILLER_0_54_617 VGND VGND VPWR VPWR sky130_fd_sc_hd__fill_1
XPHY_255 VGND VGND VPWR VPWR sky130_fd_sc_hd__decap_3
XPHY_266 VGND VGND VPWR VPWR sky130_fd_sc_hd__decap_3
XPHY_299 VGND VGND VPWR VPWR sky130_fd_sc_hd__decap_3
XFILLER_0_30_29 VPWR VGND VPWR VGND sky130_ef_sc_hd__decap_12
XPHY_288 VGND VGND VPWR VPWR sky130_fd_sc_hd__decap_3
XFILLER_0_87_1237 VPWR VGND VPWR VGND sky130_ef_sc_hd__decap_12
XFILLER_0_105_741 VPWR VGND VPWR VGND sky130_ef_sc_hd__decap_12
XFILLER_0_105_785 VPWR VGND VPWR VGND sky130_ef_sc_hd__decap_12
XFILLER_0_132_593 VPWR VGND VPWR VGND sky130_ef_sc_hd__decap_12
XFILLER_0_39_27 VPWR VGND VPWR VGND sky130_ef_sc_hd__decap_12
XFILLER_0_197_1225 VPWR VGND VPWR VGND sky130_ef_sc_hd__decap_12
XFILLER_0_219_653 VPWR VGND VPWR VGND sky130_ef_sc_hd__decap_12
XFILLER_0_218_141 VPWR VGND VPWR VGND sky130_ef_sc_hd__decap_12
XFILLER_0_219_697 VPWR VGND VPWR VGND sky130_ef_sc_hd__decap_12
XFILLER_0_55_15 VPWR VGND VPWR VGND sky130_ef_sc_hd__decap_12
XFILLER_0_226_72 VPWR VGND VPWR VGND sky130_ef_sc_hd__decap_12
XFILLER_0_226_50 VGND VGND VPWR VPWR sky130_fd_sc_hd__decap_6
XFILLER_0_221_317 VPWR VGND VPWR VGND sky130_ef_sc_hd__decap_12
XFILLER_0_199_593 VPWR VGND VPWR VGND sky130_ef_sc_hd__decap_12
XFILLER_0_226_94 VPWR VGND VPWR VGND sky130_ef_sc_hd__decap_12
XFILLER_0_173_1291 VPWR VGND VPWR VGND sky130_ef_sc_hd__decap_12
XFILLER_0_71_47 VGND VGND VPWR VPWR sky130_fd_sc_hd__decap_3
XFILLER_0_162_27 VGND VGND VPWR VPWR sky130_fd_sc_hd__fill_1
XFILLER_0_162_49 VGND VGND VPWR VPWR sky130_fd_sc_hd__fill_1
XFILLER_0_134_1275 VGND VGND VPWR VPWR sky130_fd_sc_hd__decap_6
XFILLER_0_70_1263 VPWR VGND VPWR VGND sky130_ef_sc_hd__decap_12
XFILLER_0_155_641 VGND VGND VPWR VPWR sky130_fd_sc_hd__decap_4
XFILLER_0_45_617 VPWR VGND VPWR VGND sky130_ef_sc_hd__decap_12
XFILLER_0_31_1225 VPWR VGND VPWR VGND sky130_ef_sc_hd__decap_12
XFILLER_0_170_655 VGND VGND VPWR VPWR sky130_fd_sc_hd__decap_4
XFILLER_0_180_1251 VPWR VGND VPWR VGND sky130_ef_sc_hd__decap_12
XFILLER_0_141_1213 VPWR VGND VPWR VGND sky130_ef_sc_hd__decap_12
XFILLER_0_123_593 VPWR VGND VPWR VGND sky130_ef_sc_hd__decap_12
XFILLER_0_1_953 VPWR VGND VPWR VGND sky130_ef_sc_hd__decap_12
XFILLER_0_110_221 VPWR VGND VPWR VGND sky130_ef_sc_hd__decap_12
XFILLER_0_180_1295 VPWR VGND VPWR VGND sky130_ef_sc_hd__decap_12
XFILLER_0_111_777 VGND VGND VPWR VPWR sky130_fd_sc_hd__decap_6
XFILLER_0_0_463 VGND VGND VPWR VPWR sky130_fd_sc_hd__fill_2
XFILLER_0_42_1343 VGND VGND VPWR VPWR sky130_fd_sc_hd__fill_1
XFILLER_0_110_265 VPWR VGND VPWR VGND sky130_ef_sc_hd__decap_12
XFILLER_0_221_1281 VGND VGND VPWR VPWR sky130_fd_sc_hd__decap_6
XFILLER_0_141_1279 VPWR VGND VPWR VGND sky130_ef_sc_hd__decap_12
XFILLER_0_0_485 VGND VGND VPWR VPWR sky130_fd_sc_hd__fill_2
XFILLER_0_224_133 VGND VGND VPWR VPWR sky130_fd_sc_hd__decap_6
XTAP_2609 VGND VPWR sky130_fd_sc_hd__tapvpwrvgnd_1
XFILLER_0_224_177 VPWR VGND VPWR VGND sky130_ef_sc_hd__decap_12
XFILLER_0_215_1063 VGND VGND VPWR VPWR sky130_fd_sc_hd__fill_1
XFILLER_0_152_1331 VGND VGND VPWR VPWR sky130_fd_sc_hd__decap_6
XTAP_1919 VGND VPWR sky130_fd_sc_hd__tapvpwrvgnd_1
XTAP_1908 VGND VPWR sky130_fd_sc_hd__tapvpwrvgnd_1
XFILLER_0_221_895 VGND VGND VPWR VPWR sky130_fd_sc_hd__fill_1
XFILLER_0_138_619 VPWR VGND VPWR VGND sky130_ef_sc_hd__decap_12
XFILLER_0_0_83 VGND VGND VPWR VPWR sky130_fd_sc_hd__fill_1
XFILLER_0_36_617 VGND VGND VPWR VPWR sky130_fd_sc_hd__fill_1
XFILLER_0_1_1101 VPWR VGND VPWR VGND sky130_ef_sc_hd__decap_12
XFILLER_0_5_1281 VGND VGND VPWR VPWR sky130_fd_sc_hd__decap_6
XFILLER_0_1_1145 VPWR VGND VPWR VGND sky130_ef_sc_hd__decap_12
XFILLER_0_161_655 VGND VGND VPWR VPWR sky130_fd_sc_hd__fill_2
XFILLER_0_1_1189 VPWR VGND VPWR VGND sky130_ef_sc_hd__decap_12
XFILLER_0_107_1119 VGND VGND VPWR VPWR sky130_fd_sc_hd__fill_1
XFILLER_0_86_1281 VGND VGND VPWR VPWR sky130_fd_sc_hd__fill_1
XFILLER_0_216_601 VPWR VGND VPWR VGND sky130_ef_sc_hd__decap_12
XFILLER_0_120_1319 VPWR VGND VPWR VGND sky130_ef_sc_hd__decap_12
XFILLER_0_200_1343 VGND VGND VPWR VPWR sky130_fd_sc_hd__fill_1
XFILLER_0_215_111 VGND VGND VPWR VPWR sky130_fd_sc_hd__fill_1
XANTENNA_input147_A w10[8] VGND VGND VPWR VPWR sky130_fd_sc_hd__diode_2
XFILLER_0_216_645 VPWR VGND VPWR VGND sky130_ef_sc_hd__decap_12
XFILLER_0_157_1253 VGND VGND VPWR VPWR sky130_fd_sc_hd__fill_1
XFILLER_0_19_1323 VPWR VGND VPWR VGND sky130_ef_sc_hd__decap_12
XFILLER_0_54_1225 VGND VGND VPWR VPWR sky130_fd_sc_hd__fill_1
XFILLER_0_211_361 VPWR VGND VPWR VGND sky130_ef_sc_hd__decap_12
XFILLER_0_137_641 VGND VGND VPWR VPWR sky130_fd_sc_hd__decap_4
XFILLER_0_41_39 VGND VGND VPWR VPWR sky130_fd_sc_hd__decap_8
XFILLER_0_27_617 VPWR VGND VPWR VGND sky130_ef_sc_hd__decap_12
XFILLER_0_212_41 VPWR VGND VPWR VGND sky130_ef_sc_hd__decap_12
XFILLER_0_129_1311 VPWR VGND VPWR VGND sky130_ef_sc_hd__decap_12
XFILLER_0_212_85 VPWR VGND VPWR VGND sky130_ef_sc_hd__decap_12
XFILLER_0_203_9 VGND VGND VPWR VPWR sky130_fd_sc_hd__fill_2
XFILLER_0_164_1213 VPWR VGND VPWR VGND sky130_ef_sc_hd__decap_12
XANTENNA_u_pe01_act_in[3] act_00_out_01_in\[3\] VGND VGND VPWR VPWR sky130_fd_sc_hd__diode_2
XFILLER_0_152_655 VGND VGND VPWR VPWR sky130_fd_sc_hd__decap_4
XFILLER_0_1_205 VPWR VGND VPWR VGND sky130_ef_sc_hd__decap_12
XFILLER_0_50_631 VPWR VGND VPWR VGND sky130_ef_sc_hd__decap_12
XFILLER_0_199_1309 VGND VGND VPWR VPWR sky130_fd_sc_hd__fill_1
XFILLER_0_1_249 VPWR VGND VPWR VGND sky130_ef_sc_hd__decap_12
XFILLER_0_219_461 VPWR VGND VPWR VGND sky130_ef_sc_hd__decap_12
XFILLER_0_5_39 VPWR VGND VPWR VGND sky130_ef_sc_hd__decap_12
XFILLER_0_207_645 VGND VGND VPWR VPWR sky130_fd_sc_hd__fill_1
XFILLER_0_222_637 VGND VGND VPWR VPWR sky130_fd_sc_hd__decap_6
XFILLER_0_173_15 VPWR VGND VPWR VGND sky130_ef_sc_hd__decap_12
XFILLER_0_221_125 VPWR VGND VPWR VGND sky130_ef_sc_hd__decap_12
XFILLER_0_136_1337 VGND VGND VPWR VPWR sky130_fd_sc_hd__fill_1
XFILLER_0_167_3 VPWR VGND VPWR VGND sky130_ef_sc_hd__decap_12
XFILLER_0_212_1203 VGND VGND VPWR VPWR sky130_fd_sc_hd__fill_1
XFILLER_0_221_169 VPWR VGND VPWR VGND sky130_ef_sc_hd__decap_12
XFILLER_0_10_9 VGND VGND VPWR VPWR sky130_fd_sc_hd__fill_2
XFILLER_0_33_1309 VGND VGND VPWR VPWR sky130_fd_sc_hd__fill_1
XFILLER_0_106_53 VPWR VGND VPWR VGND sky130_ef_sc_hd__decap_12
XFILLER_0_106_97 VPWR VGND VPWR VGND sky130_ef_sc_hd__decap_12
XFILLER_0_18_617 VGND VGND VPWR VPWR sky130_fd_sc_hd__fill_1
XFILLER_0_122_41 VGND VGND VPWR VPWR sky130_fd_sc_hd__decap_8
XFILLER_0_143_655 VGND VGND VPWR VPWR sky130_fd_sc_hd__fill_2
XFILLER_0_223_1343 VGND VGND VPWR VPWR sky130_fd_sc_hd__fill_1
XFILLER_0_106_1141 VGND VGND VPWR VPWR sky130_fd_sc_hd__decap_6
XFILLER_0_111_541 VPWR VGND VPWR VGND sky130_ef_sc_hd__decap_12
XFILLER_0_106_1185 VPWR VGND VPWR VGND sky130_ef_sc_hd__decap_12
XFILLER_0_111_585 VPWR VGND VPWR VGND sky130_ef_sc_hd__decap_12
XFILLER_0_1_783 VGND VGND VPWR VPWR sky130_fd_sc_hd__fill_1
XFILLER_0_226_965 VGND VGND VPWR VPWR sky130_fd_sc_hd__decap_4
XFILLER_0_77_1225 VPWR VGND VPWR VGND sky130_ef_sc_hd__decap_12
XFILLER_0_213_615 VGND VGND VPWR VPWR sky130_fd_sc_hd__fill_1
XFILLER_0_225_497 VGND VGND VPWR VPWR sky130_fd_sc_hd__decap_6
XTAP_2406 VGND VPWR sky130_fd_sc_hd__tapvpwrvgnd_1
XTAP_2417 VGND VPWR sky130_fd_sc_hd__tapvpwrvgnd_1
XFILLER_0_217_1169 VGND VGND VPWR VPWR sky130_fd_sc_hd__decap_6
XTAP_2439 VGND VPWR sky130_fd_sc_hd__tapvpwrvgnd_1
XTAP_2428 VGND VPWR sky130_fd_sc_hd__tapvpwrvgnd_1
XTAP_1705 VGND VPWR sky130_fd_sc_hd__tapvpwrvgnd_1
XFILLER_0_113_1101 VPWR VGND VPWR VGND sky130_ef_sc_hd__decap_12
XTAP_1749 VGND VPWR sky130_fd_sc_hd__tapvpwrvgnd_1
XTAP_1738 VGND VPWR sky130_fd_sc_hd__tapvpwrvgnd_1
XTAP_1716 VGND VPWR sky130_fd_sc_hd__tapvpwrvgnd_1
XTAP_1727 VGND VPWR sky130_fd_sc_hd__tapvpwrvgnd_1
XFILLER_0_187_1213 VPWR VGND VPWR VGND sky130_ef_sc_hd__decap_12
XFILLER_0_113_1145 VPWR VGND VPWR VGND sky130_ef_sc_hd__decap_12
XFILLER_0_113_1189 VPWR VGND VPWR VGND sky130_ef_sc_hd__decap_12
XFILLER_0_119_641 VGND VGND VPWR VPWR sky130_fd_sc_hd__decap_4
XFILLER_0_14_1275 VGND VGND VPWR VPWR sky130_fd_sc_hd__decap_6
XFILLER_0_53_1291 VPWR VGND VPWR VGND sky130_ef_sc_hd__decap_12
XFILLER_0_187_1279 VPWR VGND VPWR VGND sky130_ef_sc_hd__decap_12
XFILLER_0_88_1343 VGND VGND VPWR VPWR sky130_fd_sc_hd__fill_1
XFILLER_0_134_655 VGND VGND VPWR VPWR sky130_fd_sc_hd__decap_4
XFILLER_0_106_357 VGND VGND VPWR VPWR sky130_fd_sc_hd__decap_6
XFILLER_0_224_1129 VPWR VGND VPWR VGND sky130_ef_sc_hd__decap_12
XFILLER_0_32_631 VPWR VGND VPWR VGND sky130_ef_sc_hd__decap_12
XFILLER_0_198_1331 VGND VGND VPWR VPWR sky130_fd_sc_hd__decap_6
XFILLER_0_124_1263 VPWR VGND VPWR VGND sky130_ef_sc_hd__decap_12
XFILLER_0_60_1251 VPWR VGND VPWR VGND sky130_ef_sc_hd__decap_12
XFILLER_0_217_921 VPWR VGND VPWR VGND sky130_ef_sc_hd__decap_12
XFILLER_0_21_1213 VPWR VGND VPWR VGND sky130_ef_sc_hd__decap_12
XFILLER_0_194_1239 VPWR VGND VPWR VGND sky130_ef_sc_hd__decap_12
XFILLER_0_217_965 VPWR VGND VPWR VGND sky130_ef_sc_hd__decap_12
XFILLER_0_95_1303 VGND VGND VPWR VPWR sky130_fd_sc_hd__decap_6
XFILLER_0_60_1295 VPWR VGND VPWR VGND sky130_ef_sc_hd__decap_12
XFILLER_0_216_475 VGND VGND VPWR VPWR sky130_fd_sc_hd__fill_1
XFILLER_0_21_1279 VPWR VGND VPWR VGND sky130_ef_sc_hd__decap_12
XTAP_2940 VGND VPWR sky130_fd_sc_hd__tapvpwrvgnd_1
XTAP_2962 VGND VPWR sky130_fd_sc_hd__tapvpwrvgnd_1
XTAP_2951 VGND VPWR sky130_fd_sc_hd__tapvpwrvgnd_1
XFILLER_0_212_681 VPWR VGND VPWR VGND sky130_ef_sc_hd__decap_12
XFILLER_0_131_1201 VPWR VGND VPWR VGND sky130_ef_sc_hd__decap_12
XFILLER_0_223_51 VGND VGND VPWR VPWR sky130_fd_sc_hd__decap_4
XFILLER_0_170_1283 VPWR VGND VPWR VGND sky130_ef_sc_hd__decap_12
XFILLER_0_52_49 VGND VGND VPWR VPWR sky130_fd_sc_hd__fill_1
XFILLER_0_32_1331 VGND VGND VPWR VPWR sky130_fd_sc_hd__decap_6
XFILLER_0_131_1267 VPWR VGND VPWR VGND sky130_ef_sc_hd__decap_12
XFILLER_0_7_809 VGND VGND VPWR VPWR sky130_fd_sc_hd__decap_3
XFILLER_0_166_1319 VPWR VGND VPWR VGND sky130_ef_sc_hd__decap_12
XFILLER_0_113_839 VGND VGND VPWR VPWR sky130_fd_sc_hd__fill_1
XFILLER_0_2_525 VGND VGND VPWR VPWR sky130_fd_sc_hd__decap_6
XFILLER_0_2_569 VPWR VGND VPWR VGND sky130_ef_sc_hd__decap_12
XFILLER_0_77_46 VGND VGND VPWR VPWR sky130_fd_sc_hd__decap_4
XFILLER_0_103_1303 VGND VGND VPWR VPWR sky130_fd_sc_hd__decap_6
XFILLER_0_226_228 VGND VGND VPWR VPWR sky130_fd_sc_hd__fill_2
XFILLER_0_222_401 VPWR VGND VPWR VGND sky130_ef_sc_hd__decap_12
XFILLER_0_222_445 VPWR VGND VPWR VGND sky130_ef_sc_hd__decap_12
XFILLER_0_214_1309 VGND VGND VPWR VPWR sky130_fd_sc_hd__decap_6
XFILLER_0_210_629 VPWR VGND VPWR VGND sky130_ef_sc_hd__decap_12
XFILLER_0_222_489 VPWR VGND VPWR VGND sky130_ef_sc_hd__decap_12
XFILLER_0_37_1253 VGND VGND VPWR VPWR sky130_fd_sc_hd__fill_1
XFILLER_0_110_1329 VPWR VGND VPWR VGND sky130_ef_sc_hd__decap_12
XFILLER_0_116_655 VGND VGND VPWR VPWR sky130_fd_sc_hd__decap_4
XFILLER_0_2_1273 VPWR VGND VPWR VGND sky130_ef_sc_hd__decap_12
XFILLER_0_108_1203 VGND VGND VPWR VPWR sky130_fd_sc_hd__fill_1
XFILLER_0_14_631 VPWR VGND VPWR VGND sky130_ef_sc_hd__decap_12
XFILLER_0_131_647 VGND VGND VPWR VPWR sky130_fd_sc_hd__decap_8
XFILLER_0_5_385 VGND VGND VPWR VPWR sky130_fd_sc_hd__decap_6
XFILLER_0_44_1213 VPWR VGND VPWR VGND sky130_ef_sc_hd__decap_12
XANTENNA_u_pe01_psum_in[19] net76 VGND VGND VPWR VPWR sky130_fd_sc_hd__diode_2
XFILLER_0_112_861 VGND VGND VPWR VPWR sky130_fd_sc_hd__decap_6
XFILLER_0_217_217 VGND VGND VPWR VPWR sky130_fd_sc_hd__decap_6
XFILLER_0_79_1309 VGND VGND VPWR VPWR sky130_fd_sc_hd__fill_1
XFILLER_0_111_393 VPWR VGND VPWR VGND sky130_ef_sc_hd__decap_12
XFILLER_0_225_261 VPWR VGND VPWR VGND sky130_ef_sc_hd__decap_12
XFILLER_0_154_1201 VPWR VGND VPWR VGND sky130_ef_sc_hd__decap_12
XFILLER_0_214_979 VGND VGND VPWR VPWR sky130_fd_sc_hd__fill_1
XTAP_2203 VGND VPWR sky130_fd_sc_hd__tapvpwrvgnd_1
XTAP_2214 VGND VPWR sky130_fd_sc_hd__tapvpwrvgnd_1
XTAP_2225 VGND VPWR sky130_fd_sc_hd__tapvpwrvgnd_1
XFILLER_0_201_629 VPWR VGND VPWR VGND sky130_ef_sc_hd__decap_12
XTAP_2269 VGND VPWR sky130_fd_sc_hd__tapvpwrvgnd_1
XTAP_2247 VGND VPWR sky130_fd_sc_hd__tapvpwrvgnd_1
XTAP_2236 VGND VPWR sky130_fd_sc_hd__tapvpwrvgnd_1
XTAP_2258 VGND VPWR sky130_fd_sc_hd__tapvpwrvgnd_1
XPHY_31 VGND VGND VPWR VPWR sky130_fd_sc_hd__decap_3
XTAP_1502 VGND VPWR sky130_fd_sc_hd__tapvpwrvgnd_1
XPHY_20 VGND VGND VPWR VPWR sky130_fd_sc_hd__decap_3
XTAP_1513 VGND VPWR sky130_fd_sc_hd__tapvpwrvgnd_1
XTAP_1524 VGND VPWR sky130_fd_sc_hd__tapvpwrvgnd_1
XTAP_1557 VGND VPWR sky130_fd_sc_hd__tapvpwrvgnd_1
XPHY_64 VGND VGND VPWR VPWR sky130_fd_sc_hd__decap_3
XPHY_53 VGND VGND VPWR VPWR sky130_fd_sc_hd__decap_3
XPHY_42 VGND VGND VPWR VPWR sky130_fd_sc_hd__decap_3
XTAP_1546 VGND VPWR sky130_fd_sc_hd__tapvpwrvgnd_1
XFILLER_0_16_1337 VGND VGND VPWR VPWR sky130_fd_sc_hd__fill_1
XTAP_1535 VGND VPWR sky130_fd_sc_hd__tapvpwrvgnd_1
XPHY_97 VGND VGND VPWR VPWR sky130_fd_sc_hd__decap_3
XFILLER_0_7_1173 VGND VGND VPWR VPWR sky130_fd_sc_hd__decap_3
XPHY_75 VGND VGND VPWR VPWR sky130_fd_sc_hd__decap_3
XPHY_86 VGND VGND VPWR VPWR sky130_fd_sc_hd__decap_3
XTAP_1568 VGND VPWR sky130_fd_sc_hd__tapvpwrvgnd_1
XTAP_1579 VGND VPWR sky130_fd_sc_hd__tapvpwrvgnd_1
XFILLER_0_106_121 VPWR VGND VPWR VGND sky130_ef_sc_hd__decap_12
XFILLER_0_106_165 VPWR VGND VPWR VGND sky130_ef_sc_hd__decap_12
XANTENNA_input75_A psum_col1_in[18] VGND VGND VPWR VPWR sky130_fd_sc_hd__diode_2
XFILLER_0_161_1249 VGND VGND VPWR VPWR sky130_fd_sc_hd__decap_4
XFILLER_0_202_1213 VPWR VGND VPWR VGND sky130_ef_sc_hd__decap_12
XFILLER_0_47_27 VPWR VGND VPWR VGND sky130_ef_sc_hd__decap_12
XFILLER_0_138_29 VPWR VGND VPWR VGND sky130_ef_sc_hd__decap_12
XFILLER_0_99_1291 VPWR VGND VPWR VGND sky130_ef_sc_hd__decap_12
XFILLER_0_2_29 VPWR VGND VPWR VGND sky130_ef_sc_hd__decap_12
XFILLER_0_220_905 VPWR VGND VPWR VGND sky130_ef_sc_hd__decap_12
XFILLER_0_189_647 VPWR VGND VPWR VGND sky130_ef_sc_hd__decap_12
XFILLER_0_220_949 VPWR VGND VPWR VGND sky130_ef_sc_hd__decap_12
XFILLER_0_87_645 VGND VGND VPWR VPWR sky130_fd_sc_hd__fill_1
XTAP_2770 VGND VPWR sky130_fd_sc_hd__tapvpwrvgnd_1
XTAP_2781 VGND VPWR sky130_fd_sc_hd__tapvpwrvgnd_1
XTAP_2792 VGND VPWR sky130_fd_sc_hd__tapvpwrvgnd_1
XFILLER_0_170_27 VGND VGND VPWR VPWR sky130_fd_sc_hd__fill_1
XFILLER_0_170_49 VGND VGND VPWR VPWR sky130_fd_sc_hd__fill_1
XFILLER_0_7_617 VPWR VGND VPWR VGND sky130_ef_sc_hd__decap_12
XFILLER_0_12_41 VGND VGND VPWR VPWR sky130_fd_sc_hd__decap_8
XFILLER_0_67_1213 VPWR VGND VPWR VGND sky130_ef_sc_hd__decap_12
XFILLER_0_179_47 VGND VGND VPWR VPWR sky130_fd_sc_hd__fill_1
XFILLER_0_67_1279 VPWR VGND VPWR VGND sky130_ef_sc_hd__decap_12
XFILLER_0_3_889 VGND VGND VPWR VPWR sky130_fd_sc_hd__decap_6
XFILLER_0_2_333 VPWR VGND VPWR VGND sky130_ef_sc_hd__decap_12
XFILLER_0_2_377 VPWR VGND VPWR VGND sky130_ef_sc_hd__decap_12
XFILLER_0_11_645 VGND VGND VPWR VPWR sky130_fd_sc_hd__fill_1
XFILLER_0_177_1201 VPWR VGND VPWR VGND sky130_ef_sc_hd__decap_12
Xoutput169 net169 VGND VGND VPWR VPWR psum_col0_out[13] sky130_fd_sc_hd__clkbuf_4
XFILLER_0_177_1267 VPWR VGND VPWR VGND sky130_ef_sc_hd__decap_12
XFILLER_0_214_209 VPWR VGND VPWR VGND sky130_ef_sc_hd__decap_12
XFILLER_0_78_1331 VGND VGND VPWR VPWR sky130_fd_sc_hd__decap_6
XFILLER_0_223_721 VGND VGND VPWR VPWR sky130_fd_sc_hd__decap_6
XFILLER_0_218_1253 VGND VGND VPWR VPWR sky130_fd_sc_hd__decap_6
XFILLER_0_223_765 VPWR VGND VPWR VGND sky130_ef_sc_hd__decap_12
XFILLER_0_222_253 VPWR VGND VPWR VGND sky130_ef_sc_hd__decap_12
XFILLER_0_74_1239 VPWR VGND VPWR VGND sky130_ef_sc_hd__decap_12
XFILLER_0_218_1297 VPWR VGND VPWR VGND sky130_ef_sc_hd__decap_12
XFILLER_0_214_1117 VPWR VGND VPWR VGND sky130_ef_sc_hd__decap_12
XFILLER_0_195_617 VPWR VGND VPWR VGND sky130_ef_sc_hd__decap_12
XPHY_607 VGND VGND VPWR VPWR sky130_fd_sc_hd__decap_3
XPHY_618 VGND VGND VPWR VPWR sky130_fd_sc_hd__decap_3
XFILLER_0_114_1273 VPWR VGND VPWR VGND sky130_ef_sc_hd__decap_12
XPHY_629 VGND VGND VPWR VPWR sky130_fd_sc_hd__decap_3
XFILLER_0_109_909 VPWR VGND VPWR VGND sky130_ef_sc_hd__decap_12
XPHY_1217 VGND VGND VPWR VPWR sky130_fd_sc_hd__decap_3
XPHY_1206 VGND VGND VPWR VPWR sky130_fd_sc_hd__decap_3
XFILLER_0_149_1303 VGND VGND VPWR VPWR sky130_fd_sc_hd__decap_6
XFILLER_0_11_1201 VPWR VGND VPWR VGND sky130_ef_sc_hd__decap_12
XFILLER_0_108_419 VGND VGND VPWR VPWR sky130_fd_sc_hd__fill_1
XFILLER_0_184_1227 VPWR VGND VPWR VGND sky130_ef_sc_hd__decap_12
XFILLER_0_50_1283 VPWR VGND VPWR VGND sky130_ef_sc_hd__decap_12
XFILLER_0_11_1267 VPWR VGND VPWR VGND sky130_ef_sc_hd__decap_12
XFILLER_0_85_1335 VGND VGND VPWR VPWR sky130_fd_sc_hd__decap_8
XFILLER_0_225_1213 VPWR VGND VPWR VGND sky130_ef_sc_hd__decap_12
XFILLER_0_46_1319 VPWR VGND VPWR VGND sky130_ef_sc_hd__decap_12
XFILLER_0_225_1257 VPWR VGND VPWR VGND sky130_ef_sc_hd__decap_12
XFILLER_0_104_669 VGND VGND VPWR VPWR sky130_fd_sc_hd__decap_3
XFILLER_0_5_193 VPWR VGND VPWR VGND sky130_ef_sc_hd__decap_12
XFILLER_0_195_1323 VPWR VGND VPWR VGND sky130_ef_sc_hd__decap_12
XFILLER_0_121_1255 VPWR VGND VPWR VGND sky130_ef_sc_hd__decap_12
XFILLER_0_156_1307 VPWR VGND VPWR VGND sky130_ef_sc_hd__decap_12
XTAP_2000 VGND VPWR sky130_fd_sc_hd__tapvpwrvgnd_1
XFILLER_0_92_1339 VGND VGND VPWR VPWR sky130_fd_sc_hd__decap_4
XFILLER_0_9_1213 VPWR VGND VPWR VGND sky130_ef_sc_hd__decap_12
XFILLER_0_186_617 VGND VGND VPWR VPWR sky130_fd_sc_hd__fill_1
XTAP_2022 VGND VPWR sky130_fd_sc_hd__tapvpwrvgnd_1
XTAP_2033 VGND VPWR sky130_fd_sc_hd__tapvpwrvgnd_1
XTAP_2011 VGND VPWR sky130_fd_sc_hd__tapvpwrvgnd_1
XFILLER_0_69_645 VGND VGND VPWR VPWR sky130_fd_sc_hd__fill_1
XTAP_2066 VGND VPWR sky130_fd_sc_hd__tapvpwrvgnd_1
XTAP_2044 VGND VPWR sky130_fd_sc_hd__tapvpwrvgnd_1
XTAP_1321 VGND VPWR sky130_fd_sc_hd__tapvpwrvgnd_1
XTAP_1310 VGND VPWR sky130_fd_sc_hd__tapvpwrvgnd_1
XTAP_1332 VGND VPWR sky130_fd_sc_hd__tapvpwrvgnd_1
XFILLER_0_9_1279 VPWR VGND VPWR VGND sky130_ef_sc_hd__decap_12
XTAP_2077 VGND VPWR sky130_fd_sc_hd__tapvpwrvgnd_1
XTAP_2055 VGND VPWR sky130_fd_sc_hd__tapvpwrvgnd_1
XTAP_2088 VGND VPWR sky130_fd_sc_hd__tapvpwrvgnd_1
XTAP_1365 VGND VPWR sky130_fd_sc_hd__tapvpwrvgnd_1
XTAP_1343 VGND VPWR sky130_fd_sc_hd__tapvpwrvgnd_1
XTAP_1354 VGND VPWR sky130_fd_sc_hd__tapvpwrvgnd_1
XTAP_2099 VGND VPWR sky130_fd_sc_hd__tapvpwrvgnd_1
XTAP_1387 VGND VPWR sky130_fd_sc_hd__tapvpwrvgnd_1
XTAP_1398 VGND VPWR sky130_fd_sc_hd__tapvpwrvgnd_1
XTAP_1376 VGND VPWR sky130_fd_sc_hd__tapvpwrvgnd_1
Xinput27 act_row1_in[4] VGND VGND VPWR VPWR net27 sky130_fd_sc_hd__buf_1
Xinput16 act_row0_in[9] VGND VGND VPWR VPWR net16 sky130_fd_sc_hd__clkbuf_4
XFILLER_0_107_441 VGND VGND VPWR VPWR sky130_fd_sc_hd__decap_6
Xinput49 psum_col0_in[23] VGND VGND VPWR VPWR net49 sky130_fd_sc_hd__buf_1
Xinput38 psum_col0_in[13] VGND VGND VPWR VPWR net38 sky130_fd_sc_hd__buf_1
XFILLER_0_220_41 VPWR VGND VPWR VGND sky130_ef_sc_hd__decap_12
XFILLER_0_107_485 VPWR VGND VPWR VGND sky130_ef_sc_hd__decap_12
XFILLER_0_204_1319 VPWR VGND VPWR VGND sky130_ef_sc_hd__decap_12
XFILLER_0_220_85 VPWR VGND VPWR VGND sky130_ef_sc_hd__decap_12
XFILLER_0_58_15 VPWR VGND VPWR VGND sky130_ef_sc_hd__decap_12
XFILLER_0_149_39 VGND VGND VPWR VPWR sky130_fd_sc_hd__decap_8
XFILLER_0_0_859 VGND VGND VPWR VPWR sky130_fd_sc_hd__fill_2
XFILLER_0_100_1339 VGND VGND VPWR VPWR sky130_fd_sc_hd__decap_4
XFILLER_0_165_27 VPWR VGND VPWR VGND sky130_ef_sc_hd__decap_12
XFILLER_0_220_713 VPWR VGND VPWR VGND sky130_ef_sc_hd__decap_12
XFILLER_0_177_617 VPWR VGND VPWR VGND sky130_ef_sc_hd__decap_12
XFILLER_0_181_15 VPWR VGND VPWR VGND sky130_ef_sc_hd__decap_12
XFILLER_0_220_757 VPWR VGND VPWR VGND sky130_ef_sc_hd__decap_12
XFILLER_0_34_1201 VPWR VGND VPWR VGND sky130_ef_sc_hd__decap_12
XFILLER_0_114_53 VGND VGND VPWR VPWR sky130_fd_sc_hd__decap_3
XFILLER_0_114_97 VPWR VGND VPWR VGND sky130_ef_sc_hd__decap_12
XFILLER_0_130_41 VGND VGND VPWR VPWR sky130_fd_sc_hd__decap_8
XFILLER_0_3_653 VPWR VGND VPWR VGND sky130_ef_sc_hd__decap_12
XFILLER_0_101_617 VPWR VGND VPWR VGND sky130_ef_sc_hd__decap_12
XFILLER_0_3_697 VPWR VGND VPWR VGND sky130_ef_sc_hd__decap_12
XFILLER_0_2_141 VPWR VGND VPWR VGND sky130_ef_sc_hd__decap_12
XFILLER_0_54_3 VPWR VGND VPWR VGND sky130_ef_sc_hd__decap_12
XFILLER_0_41_1249 VGND VGND VPWR VPWR sky130_fd_sc_hd__decap_4
XFILLER_0_215_529 VPWR VGND VPWR VGND sky130_ef_sc_hd__decap_12
XFILLER_0_218_1061 VPWR VGND VPWR VGND sky130_ef_sc_hd__decap_12
XFILLER_0_223_573 VPWR VGND VPWR VGND sky130_ef_sc_hd__decap_12
XFILLER_0_168_617 VGND VGND VPWR VPWR sky130_fd_sc_hd__fill_1
XFILLER_0_190_1275 VGND VGND VPWR VPWR sky130_fd_sc_hd__decap_6
XFILLER_0_151_1237 VPWR VGND VPWR VGND sky130_ef_sc_hd__decap_12
XPHY_426 VGND VGND VPWR VPWR sky130_fd_sc_hd__decap_3
XPHY_415 VGND VGND VPWR VPWR sky130_fd_sc_hd__decap_3
XPHY_404 VGND VGND VPWR VPWR sky130_fd_sc_hd__decap_3
XPHY_1014 VGND VGND VPWR VPWR sky130_fd_sc_hd__decap_3
XPHY_1003 VGND VGND VPWR VPWR sky130_fd_sc_hd__decap_3
XPHY_437 VGND VGND VPWR VPWR sky130_fd_sc_hd__decap_3
XPHY_448 VGND VGND VPWR VPWR sky130_fd_sc_hd__decap_3
XPHY_459 VGND VGND VPWR VPWR sky130_fd_sc_hd__decap_3
XPHY_1036 VGND VGND VPWR VPWR sky130_fd_sc_hd__decap_3
XPHY_1025 VGND VGND VPWR VPWR sky130_fd_sc_hd__decap_3
XPHY_1047 VGND VGND VPWR VPWR sky130_fd_sc_hd__decap_3
XFILLER_0_81_629 VPWR VGND VPWR VGND sky130_ef_sc_hd__decap_12
XFILLER_0_0_1007 VGND VGND VPWR VPWR sky130_fd_sc_hd__fill_1
XPHY_1069 VGND VGND VPWR VPWR sky130_fd_sc_hd__decap_3
XPHY_1058 VGND VGND VPWR VPWR sky130_fd_sc_hd__decap_3
XFILLER_0_105_945 VGND VGND VPWR VPWR sky130_fd_sc_hd__decap_6
XFILLER_0_7_981 VPWR VGND VPWR VGND sky130_ef_sc_hd__decap_12
XFILLER_0_225_1021 VPWR VGND VPWR VGND sky130_ef_sc_hd__decap_12
XFILLER_0_104_433 VPWR VGND VPWR VGND sky130_ef_sc_hd__decap_12
XFILLER_0_225_1065 VPWR VGND VPWR VGND sky130_ef_sc_hd__decap_12
XFILLER_0_105_989 VPWR VGND VPWR VGND sky130_ef_sc_hd__decap_12
XFILLER_0_104_477 VPWR VGND VPWR VGND sky130_ef_sc_hd__decap_12
XFILLER_0_218_301 VGND VGND VPWR VPWR sky130_fd_sc_hd__decap_6
XFILLER_0_218_345 VPWR VGND VPWR VGND sky130_ef_sc_hd__decap_12
XFILLER_0_28_29 VPWR VGND VPWR VGND sky130_ef_sc_hd__decap_12
XANTENNA_input38_A psum_col0_in[13] VGND VGND VPWR VPWR sky130_fd_sc_hd__diode_2
XFILLER_0_218_389 VPWR VGND VPWR VGND sky130_ef_sc_hd__decap_12
XFILLER_0_57_1201 VPWR VGND VPWR VGND sky130_ef_sc_hd__decap_12
XFILLER_0_96_1283 VPWR VGND VPWR VGND sky130_ef_sc_hd__decap_12
XFILLER_0_159_617 VPWR VGND VPWR VGND sky130_ef_sc_hd__decap_12
XFILLER_0_57_1267 VPWR VGND VPWR VGND sky130_ef_sc_hd__decap_12
XFILLER_0_210_1301 VPWR VGND VPWR VGND sky130_ef_sc_hd__decap_12
XFILLER_0_60_27 VGND VGND VPWR VPWR sky130_fd_sc_hd__fill_1
XFILLER_0_182_631 VPWR VGND VPWR VGND sky130_ef_sc_hd__decap_12
XPHY_960 VGND VGND VPWR VPWR sky130_fd_sc_hd__decap_3
XPHY_971 VGND VGND VPWR VPWR sky130_fd_sc_hd__decap_3
XFILLER_0_60_49 VGND VGND VPWR VPWR sky130_fd_sc_hd__fill_1
XPHY_982 VGND VGND VPWR VPWR sky130_fd_sc_hd__decap_3
XPHY_993 VGND VGND VPWR VPWR sky130_fd_sc_hd__decap_3
XFILLER_0_167_1255 VPWR VGND VPWR VGND sky130_ef_sc_hd__decap_12
XFILLER_0_128_1239 VPWR VGND VPWR VGND sky130_ef_sc_hd__decap_12
XFILLER_0_29_1303 VGND VGND VPWR VPWR sky130_fd_sc_hd__decap_6
XFILLER_0_208_1263 VPWR VGND VPWR VGND sky130_ef_sc_hd__decap_12
XFILLER_0_69_47 VGND VGND VPWR VPWR sky130_fd_sc_hd__decap_3
XFILLER_0_64_1227 VPWR VGND VPWR VGND sky130_ef_sc_hd__decap_12
XFILLER_0_107_293 VPWR VGND VPWR VGND sky130_ef_sc_hd__decap_12
XFILLER_0_197_3 VPWR VGND VPWR VGND sky130_ef_sc_hd__decap_12
XFILLER_0_176_15 VPWR VGND VPWR VGND sky130_ef_sc_hd__decap_12
XFILLER_0_104_1261 VPWR VGND VPWR VGND sky130_ef_sc_hd__decap_12
XFILLER_0_110_469 VGND VGND VPWR VPWR sky130_fd_sc_hd__decap_6
XFILLER_0_139_1335 VGND VGND VPWR VPWR sky130_fd_sc_hd__decap_8
XFILLER_0_192_25 VGND VGND VPWR VPWR sky130_fd_sc_hd__decap_3
XFILLER_0_75_1323 VPWR VGND VPWR VGND sky130_ef_sc_hd__decap_12
XFILLER_0_215_1201 VPWR VGND VPWR VGND sky130_ef_sc_hd__decap_12
XFILLER_0_36_1307 VPWR VGND VPWR VGND sky130_ef_sc_hd__decap_12
XFILLER_0_215_1245 VPWR VGND VPWR VGND sky130_ef_sc_hd__decap_12
XFILLER_0_215_1289 VPWR VGND VPWR VGND sky130_ef_sc_hd__decap_12
XFILLER_0_220_587 VGND VGND VPWR VPWR sky130_fd_sc_hd__fill_1
XFILLER_0_185_1311 VPWR VGND VPWR VGND sky130_ef_sc_hd__decap_12
XFILLER_0_150_1281 VGND VGND VPWR VPWR sky130_fd_sc_hd__fill_1
XFILLER_0_63_629 VPWR VGND VPWR VGND sky130_ef_sc_hd__decap_12
XFILLER_0_111_1287 VGND VGND VPWR VPWR sky130_fd_sc_hd__fill_1
XFILLER_0_1_1338 VGND VGND VPWR VPWR sky130_fd_sc_hd__decap_6
XFILLER_0_7_277 VGND VGND VPWR VPWR sky130_fd_sc_hd__decap_3
XFILLER_0_146_1339 VGND VGND VPWR VPWR sky130_fd_sc_hd__decap_4
XANTENNA_u_pe01_weight_in[6] net129 VGND VGND VPWR VPWR sky130_fd_sc_hd__diode_2
XFILLER_0_114_753 VGND VGND VPWR VPWR sky130_fd_sc_hd__decap_3
XFILLER_0_222_1205 VPWR VGND VPWR VGND sky130_ef_sc_hd__decap_12
XFILLER_0_114_797 VPWR VGND VPWR VGND sky130_ef_sc_hd__decap_12
XFILLER_0_3_461 VPWR VGND VPWR VGND sky130_ef_sc_hd__decap_12
XFILLER_0_4_973 VGND VGND VPWR VPWR sky130_fd_sc_hd__decap_6
XFILLER_0_216_805 VGND VGND VPWR VPWR sky130_fd_sc_hd__decap_6
XFILLER_0_110_981 VPWR VGND VPWR VGND sky130_ef_sc_hd__decap_12
XFILLER_0_216_849 VPWR VGND VPWR VGND sky130_ef_sc_hd__decap_12
XFILLER_0_215_337 VPWR VGND VPWR VGND sky130_ef_sc_hd__decap_12
XFILLER_0_192_1337 VGND VGND VPWR VPWR sky130_fd_sc_hd__fill_1
XFILLER_0_224_893 VPWR VGND VPWR VGND sky130_ef_sc_hd__decap_12
XFILLER_0_6_1205 VPWR VGND VPWR VGND sky130_ef_sc_hd__decap_12
XPHY_201 VGND VGND VPWR VPWR sky130_fd_sc_hd__decap_3
XFILLER_0_112_1029 VGND VGND VPWR VPWR sky130_fd_sc_hd__decap_6
XFILLER_0_109_503 VGND VGND VPWR VPWR sky130_fd_sc_hd__fill_1
XPHY_223 VGND VGND VPWR VPWR sky130_fd_sc_hd__decap_3
XPHY_234 VGND VGND VPWR VPWR sky130_fd_sc_hd__decap_3
XPHY_212 VGND VGND VPWR VPWR sky130_fd_sc_hd__decap_3
XFILLER_0_164_631 VPWR VGND VPWR VGND sky130_ef_sc_hd__decap_12
XPHY_256 VGND VGND VPWR VPWR sky130_fd_sc_hd__decap_3
XPHY_245 VGND VGND VPWR VPWR sky130_fd_sc_hd__decap_3
XPHY_267 VGND VGND VPWR VPWR sky130_fd_sc_hd__decap_3
XPHY_289 VGND VGND VPWR VPWR sky130_fd_sc_hd__decap_3
XPHY_278 VGND VGND VPWR VPWR sky130_fd_sc_hd__decap_3
XFILLER_0_87_1249 VGND VGND VPWR VPWR sky130_fd_sc_hd__decap_4
XFILLER_0_105_753 VPWR VGND VPWR VGND sky130_ef_sc_hd__decap_12
XFILLER_0_105_797 VPWR VGND VPWR VGND sky130_ef_sc_hd__decap_12
XFILLER_0_39_39 VGND VGND VPWR VPWR sky130_fd_sc_hd__decap_8
XFILLER_0_197_1237 VPWR VGND VPWR VGND sky130_ef_sc_hd__decap_12
XFILLER_0_219_665 VGND VGND VPWR VPWR sky130_fd_sc_hd__decap_6
XFILLER_0_218_153 VPWR VGND VPWR VGND sky130_ef_sc_hd__decap_12
XFILLER_0_146_29 VPWR VGND VPWR VGND sky130_ef_sc_hd__decap_12
XFILLER_0_218_197 VPWR VGND VPWR VGND sky130_ef_sc_hd__decap_12
XFILLER_0_55_27 VPWR VGND VPWR VGND sky130_ef_sc_hd__decap_12
XFILLER_0_221_329 VGND VGND VPWR VPWR sky130_fd_sc_hd__decap_6
XFILLER_0_71_15 VPWR VGND VPWR VGND sky130_ef_sc_hd__decap_12
XFILLER_0_210_1153 VGND VGND VPWR VPWR sky130_fd_sc_hd__decap_8
XFILLER_0_45_629 VPWR VGND VPWR VGND sky130_ef_sc_hd__decap_12
XFILLER_0_31_1237 VPWR VGND VPWR VGND sky130_ef_sc_hd__decap_12
XFILLER_0_70_1275 VGND VGND VPWR VPWR sky130_fd_sc_hd__decap_6
XPHY_790 VGND VGND VPWR VPWR sky130_fd_sc_hd__decap_3
XFILLER_0_20_41 VGND VGND VPWR VPWR sky130_fd_sc_hd__decap_8
XFILLER_0_1_921 VPWR VGND VPWR VGND sky130_ef_sc_hd__decap_12
XFILLER_0_180_1263 VPWR VGND VPWR VGND sky130_ef_sc_hd__decap_12
XFILLER_0_187_47 VGND VGND VPWR VPWR sky130_fd_sc_hd__fill_1
XFILLER_0_141_1225 VPWR VGND VPWR VGND sky130_ef_sc_hd__decap_12
XFILLER_0_1_965 VPWR VGND VPWR VGND sky130_ef_sc_hd__decap_12
XFILLER_0_110_233 VPWR VGND VPWR VGND sky130_ef_sc_hd__decap_12
XFILLER_0_0_475 VGND VGND VPWR VPWR sky130_fd_sc_hd__fill_1
XFILLER_0_110_277 VPWR VGND VPWR VGND sky130_ef_sc_hd__decap_12
XFILLER_0_212_307 VGND VGND VPWR VPWR sky130_fd_sc_hd__fill_1
XFILLER_0_221_841 VPWR VGND VPWR VGND sky130_ef_sc_hd__decap_12
XFILLER_0_224_189 VGND VGND VPWR VPWR sky130_fd_sc_hd__decap_6
XFILLER_0_152_1343 VGND VGND VPWR VPWR sky130_fd_sc_hd__fill_1
XTAP_1909 VGND VPWR sky130_fd_sc_hd__tapvpwrvgnd_1
XFILLER_0_146_631 VPWR VGND VPWR VGND sky130_ef_sc_hd__decap_12
XFILLER_0_1_1113 VGND VGND VPWR VPWR sky130_fd_sc_hd__decap_6
XFILLER_0_1_1157 VPWR VGND VPWR VGND sky130_ef_sc_hd__decap_12
XFILLER_0_161_645 VGND VGND VPWR VPWR sky130_fd_sc_hd__fill_1
XFILLER_0_114_561 VPWR VGND VPWR VGND sky130_ef_sc_hd__decap_12
XFILLER_0_47_1255 VPWR VGND VPWR VGND sky130_ef_sc_hd__decap_12
XFILLER_0_222_1035 VGND VGND VPWR VPWR sky130_fd_sc_hd__fill_1
XFILLER_0_4_781 VPWR VGND VPWR VGND sky130_ef_sc_hd__decap_12
XFILLER_0_216_613 VPWR VGND VPWR VGND sky130_ef_sc_hd__decap_12
XFILLER_0_196_1281 VGND VGND VPWR VPWR sky130_fd_sc_hd__fill_1
XFILLER_0_216_657 VPWR VGND VPWR VGND sky130_ef_sc_hd__decap_12
XFILLER_0_215_167 VGND VGND VPWR VPWR sky130_fd_sc_hd__fill_1
XFILLER_0_118_1227 VPWR VGND VPWR VGND sky130_ef_sc_hd__decap_12
XFILLER_0_93_1253 VGND VGND VPWR VPWR sky130_fd_sc_hd__fill_1
XFILLER_0_19_1335 VGND VGND VPWR VPWR sky130_fd_sc_hd__decap_8
XFILLER_0_211_373 VPWR VGND VPWR VGND sky130_ef_sc_hd__decap_12
XFILLER_0_6_1035 VGND VGND VPWR VPWR sky130_fd_sc_hd__fill_1
XFILLER_0_27_629 VPWR VGND VPWR VGND sky130_ef_sc_hd__decap_12
XFILLER_0_212_53 VPWR VGND VPWR VGND sky130_ef_sc_hd__decap_12
XFILLER_0_212_97 VPWR VGND VPWR VGND sky130_ef_sc_hd__decap_12
XFILLER_0_164_1225 VGND VGND VPWR VPWR sky130_fd_sc_hd__fill_1
XFILLER_0_129_1323 VPWR VGND VPWR VGND sky130_ef_sc_hd__decap_12
XANTENNA_u_pe01_act_in[2] act_00_out_01_in\[2\] VGND VGND VPWR VPWR sky130_fd_sc_hd__diode_2
XFILLER_0_30_1281 VGND VGND VPWR VPWR sky130_fd_sc_hd__fill_1
XFILLER_0_65_1311 VPWR VGND VPWR VGND sky130_ef_sc_hd__decap_12
XFILLER_0_105_561 VPWR VGND VPWR VGND sky130_ef_sc_hd__decap_12
XFILLER_0_50_643 VPWR VGND VPWR VGND sky130_ef_sc_hd__decap_12
XFILLER_0_1_217 VGND VGND VPWR VPWR sky130_fd_sc_hd__decap_6
XFILLER_0_26_1339 VGND VGND VPWR VPWR sky130_fd_sc_hd__decap_4
XFILLER_0_205_1255 VPWR VGND VPWR VGND sky130_ef_sc_hd__decap_12
XFILLER_0_219_473 VPWR VGND VPWR VGND sky130_ef_sc_hd__decap_12
XFILLER_0_101_1253 VGND VGND VPWR VPWR sky130_fd_sc_hd__fill_1
XFILLER_0_175_1343 VGND VGND VPWR VPWR sky130_fd_sc_hd__fill_1
XFILLER_0_173_27 VPWR VGND VPWR VGND sky130_ef_sc_hd__decap_12
XFILLER_0_221_137 VPWR VGND VPWR VGND sky130_ef_sc_hd__decap_12
XFILLER_0_72_1337 VGND VGND VPWR VPWR sky130_fd_sc_hd__fill_1
XFILLER_0_106_65 VPWR VGND VPWR VGND sky130_ef_sc_hd__decap_12
XFILLER_0_212_1259 VGND VGND VPWR VPWR sky130_fd_sc_hd__fill_1
XFILLER_0_128_631 VPWR VGND VPWR VGND sky130_ef_sc_hd__decap_12
XFILLER_0_143_645 VGND VGND VPWR VPWR sky130_fd_sc_hd__fill_1
XFILLER_0_143_1309 VGND VGND VPWR VPWR sky130_fd_sc_hd__fill_1
XFILLER_0_111_553 VGND VGND VPWR VPWR sky130_fd_sc_hd__decap_6
XFILLER_0_111_597 VPWR VGND VPWR VGND sky130_ef_sc_hd__decap_12
XFILLER_0_106_1197 VGND VGND VPWR VPWR sky130_fd_sc_hd__decap_6
XFILLER_0_77_1237 VPWR VGND VPWR VGND sky130_ef_sc_hd__decap_12
XTAP_2407 VGND VPWR sky130_fd_sc_hd__tapvpwrvgnd_1
XTAP_2418 VGND VPWR sky130_fd_sc_hd__tapvpwrvgnd_1
XTAP_2429 VGND VPWR sky130_fd_sc_hd__tapvpwrvgnd_1
XTAP_1706 VGND VPWR sky130_fd_sc_hd__tapvpwrvgnd_1
XFILLER_0_221_671 VGND VGND VPWR VPWR sky130_fd_sc_hd__fill_1
XFILLER_0_113_1113 VGND VGND VPWR VPWR sky130_fd_sc_hd__decap_6
XTAP_1717 VGND VPWR sky130_fd_sc_hd__tapvpwrvgnd_1
XTAP_1728 VGND VPWR sky130_fd_sc_hd__tapvpwrvgnd_1
XTAP_1739 VGND VPWR sky130_fd_sc_hd__tapvpwrvgnd_1
XFILLER_0_113_1157 VPWR VGND VPWR VGND sky130_ef_sc_hd__decap_12
XFILLER_0_187_1225 VPWR VGND VPWR VGND sky130_ef_sc_hd__decap_12
XFILLER_0_32_643 VPWR VGND VPWR VGND sky130_ef_sc_hd__decap_12
XFILLER_0_163_1291 VPWR VGND VPWR VGND sky130_ef_sc_hd__decap_12
XFILLER_0_198_1343 VGND VGND VPWR VPWR sky130_fd_sc_hd__fill_1
XFILLER_0_124_1275 VGND VGND VPWR VPWR sky130_fd_sc_hd__decap_6
XFILLER_0_6_3 VPWR VGND VPWR VGND sky130_ef_sc_hd__decap_12
XFILLER_0_217_933 VPWR VGND VPWR VGND sky130_ef_sc_hd__decap_12
XFILLER_0_21_1225 VPWR VGND VPWR VGND sky130_ef_sc_hd__decap_12
XFILLER_0_60_1263 VPWR VGND VPWR VGND sky130_ef_sc_hd__decap_12
XFILLER_0_216_421 VPWR VGND VPWR VGND sky130_ef_sc_hd__decap_12
XFILLER_0_217_977 VPWR VGND VPWR VGND sky130_ef_sc_hd__decap_12
XFILLER_0_204_605 VPWR VGND VPWR VGND sky130_ef_sc_hd__decap_12
XFILLER_0_36_29 VPWR VGND VPWR VGND sky130_ef_sc_hd__decap_12
XANTENNA_input20_A act_row1_in[12] VGND VGND VPWR VPWR sky130_fd_sc_hd__diode_2
XTAP_2930 VGND VPWR sky130_fd_sc_hd__tapvpwrvgnd_1
XTAP_2963 VGND VPWR sky130_fd_sc_hd__tapvpwrvgnd_1
XTAP_2952 VGND VPWR sky130_fd_sc_hd__tapvpwrvgnd_1
XTAP_2941 VGND VPWR sky130_fd_sc_hd__tapvpwrvgnd_1
XFILLER_0_212_693 VGND VGND VPWR VPWR sky130_fd_sc_hd__decap_6
XFILLER_0_170_1251 VPWR VGND VPWR VGND sky130_ef_sc_hd__decap_12
XFILLER_0_131_1213 VPWR VGND VPWR VGND sky130_ef_sc_hd__decap_12
XFILLER_0_211_181 VPWR VGND VPWR VGND sky130_ef_sc_hd__decap_12
XFILLER_0_170_1295 VPWR VGND VPWR VGND sky130_ef_sc_hd__decap_12
XFILLER_0_131_1279 VPWR VGND VPWR VGND sky130_ef_sc_hd__decap_12
XFILLER_0_32_1343 VGND VGND VPWR VPWR sky130_fd_sc_hd__fill_1
XFILLER_0_211_1281 VGND VGND VPWR VPWR sky130_fd_sc_hd__decap_6
XFILLER_0_6_309 VPWR VGND VPWR VGND sky130_ef_sc_hd__decap_12
XFILLER_0_125_645 VGND VGND VPWR VPWR sky130_fd_sc_hd__fill_1
XFILLER_0_106_881 VPWR VGND VPWR VGND sky130_ef_sc_hd__decap_12
XFILLER_0_142_1331 VGND VGND VPWR VPWR sky130_fd_sc_hd__decap_6
XFILLER_0_105_391 VGND VGND VPWR VPWR sky130_fd_sc_hd__fill_1
XFILLER_0_168_49 VGND VGND VPWR VPWR sky130_fd_sc_hd__fill_1
XFILLER_0_219_281 VPWR VGND VPWR VGND sky130_ef_sc_hd__decap_12
XFILLER_0_184_15 VPWR VGND VPWR VGND sky130_ef_sc_hd__decap_12
XFILLER_0_222_413 VGND VGND VPWR VPWR sky130_fd_sc_hd__decap_6
XFILLER_0_222_457 VPWR VGND VPWR VGND sky130_ef_sc_hd__decap_12
XFILLER_0_76_1281 VGND VGND VPWR VPWR sky130_fd_sc_hd__fill_1
XFILLER_0_2_1241 VPWR VGND VPWR VGND sky130_ef_sc_hd__decap_12
XFILLER_0_2_1285 VPWR VGND VPWR VGND sky130_ef_sc_hd__decap_12
XFILLER_0_147_1253 VGND VGND VPWR VPWR sky130_fd_sc_hd__fill_1
XFILLER_0_14_643 VPWR VGND VPWR VGND sky130_ef_sc_hd__decap_12
XANTENNA_u_pe01_psum_in[18] net75 VGND VGND VPWR VPWR sky130_fd_sc_hd__diode_2
XFILLER_0_108_1259 VGND VGND VPWR VPWR sky130_fd_sc_hd__fill_1
XFILLER_0_44_1225 VGND VGND VPWR VPWR sky130_fd_sc_hd__fill_1
XFILLER_0_111_361 VPWR VGND VPWR VGND sky130_ef_sc_hd__decap_12
XFILLER_0_6_83 VGND VGND VPWR VPWR sky130_fd_sc_hd__fill_1
XFILLER_0_226_785 VGND VGND VPWR VPWR sky130_fd_sc_hd__decap_8
XFILLER_0_214_925 VPWR VGND VPWR VGND sky130_ef_sc_hd__decap_12
XFILLER_0_225_273 VGND VGND VPWR VPWR sky130_fd_sc_hd__decap_6
XFILLER_0_154_1213 VPWR VGND VPWR VGND sky130_ef_sc_hd__decap_12
XFILLER_0_119_1311 VPWR VGND VPWR VGND sky130_ef_sc_hd__decap_12
XTAP_2215 VGND VPWR sky130_fd_sc_hd__tapvpwrvgnd_1
XTAP_2204 VGND VPWR sky130_fd_sc_hd__tapvpwrvgnd_1
XFILLER_0_90_1201 VPWR VGND VPWR VGND sky130_ef_sc_hd__decap_12
XTAP_2226 VGND VPWR sky130_fd_sc_hd__tapvpwrvgnd_1
XTAP_2259 VGND VPWR sky130_fd_sc_hd__tapvpwrvgnd_1
XTAP_2248 VGND VPWR sky130_fd_sc_hd__tapvpwrvgnd_1
XTAP_2237 VGND VPWR sky130_fd_sc_hd__tapvpwrvgnd_1
XPHY_10 VGND VGND VPWR VPWR sky130_fd_sc_hd__decap_3
XTAP_1514 VGND VPWR sky130_fd_sc_hd__tapvpwrvgnd_1
XPHY_21 VGND VGND VPWR VPWR sky130_fd_sc_hd__decap_3
XTAP_1503 VGND VPWR sky130_fd_sc_hd__tapvpwrvgnd_1
XFILLER_0_55_1343 VGND VGND VPWR VPWR sky130_fd_sc_hd__fill_1
XFILLER_0_189_1309 VGND VGND VPWR VPWR sky130_fd_sc_hd__fill_1
XTAP_1525 VGND VPWR sky130_fd_sc_hd__tapvpwrvgnd_1
XPHY_65 VGND VGND VPWR VPWR sky130_fd_sc_hd__decap_3
XPHY_43 VGND VGND VPWR VPWR sky130_fd_sc_hd__decap_3
XPHY_54 VGND VGND VPWR VPWR sky130_fd_sc_hd__decap_3
XANTENNA_u_pe11_load_weight net33 VGND VGND VPWR VPWR sky130_fd_sc_hd__diode_2
XPHY_32 VGND VGND VPWR VPWR sky130_fd_sc_hd__decap_3
XTAP_1536 VGND VPWR sky130_fd_sc_hd__tapvpwrvgnd_1
XTAP_1547 VGND VPWR sky130_fd_sc_hd__tapvpwrvgnd_1
XPHY_76 VGND VGND VPWR VPWR sky130_fd_sc_hd__decap_3
XTAP_1558 VGND VPWR sky130_fd_sc_hd__tapvpwrvgnd_1
XPHY_87 VGND VGND VPWR VPWR sky130_fd_sc_hd__decap_3
XPHY_98 VGND VGND VPWR VPWR sky130_fd_sc_hd__decap_3
XTAP_1569 VGND VPWR sky130_fd_sc_hd__tapvpwrvgnd_1
XFILLER_0_106_133 VGND VGND VPWR VPWR sky130_fd_sc_hd__decap_6
XFILLER_0_126_1337 VGND VGND VPWR VPWR sky130_fd_sc_hd__fill_1
XFILLER_0_106_177 VPWR VGND VPWR VGND sky130_ef_sc_hd__decap_12
XANTENNA_input68_A psum_col1_in[11] VGND VGND VPWR VPWR sky130_fd_sc_hd__diode_2
XFILLER_0_202_1225 VGND VGND VPWR VPWR sky130_fd_sc_hd__fill_1
XFILLER_0_23_1309 VGND VGND VPWR VPWR sky130_fd_sc_hd__fill_1
XFILLER_0_217_741 VPWR VGND VPWR VGND sky130_ef_sc_hd__decap_12
XFILLER_0_47_39 VGND VGND VPWR VPWR sky130_fd_sc_hd__decap_8
XFILLER_0_217_785 VPWR VGND VPWR VGND sky130_ef_sc_hd__decap_12
XFILLER_0_218_41 VPWR VGND VPWR VGND sky130_ef_sc_hd__decap_12
XFILLER_0_216_251 VGND VGND VPWR VPWR sky130_fd_sc_hd__fill_1
XFILLER_0_218_85 VPWR VGND VPWR VGND sky130_ef_sc_hd__decap_12
XFILLER_0_220_917 VGND VGND VPWR VPWR sky130_fd_sc_hd__decap_6
XFILLER_0_154_29 VPWR VGND VPWR VGND sky130_ef_sc_hd__decap_12
XFILLER_0_213_1343 VGND VGND VPWR VPWR sky130_fd_sc_hd__fill_1
XTAP_2771 VGND VPWR sky130_fd_sc_hd__tapvpwrvgnd_1
XTAP_2760 VGND VPWR sky130_fd_sc_hd__tapvpwrvgnd_1
XTAP_2782 VGND VPWR sky130_fd_sc_hd__tapvpwrvgnd_1
XTAP_2793 VGND VPWR sky130_fd_sc_hd__tapvpwrvgnd_1
XFILLER_0_7_629 VPWR VGND VPWR VGND sky130_ef_sc_hd__decap_12
XFILLER_0_6_139 VGND VGND VPWR VPWR sky130_fd_sc_hd__fill_1
XFILLER_0_179_15 VPWR VGND VPWR VGND sky130_ef_sc_hd__decap_12
XFILLER_0_67_1225 VPWR VGND VPWR VGND sky130_ef_sc_hd__decap_12
XFILLER_0_113_615 VGND VGND VPWR VPWR sky130_fd_sc_hd__fill_1
XFILLER_0_2_301 VGND VGND VPWR VPWR sky130_fd_sc_hd__decap_6
XFILLER_0_2_345 VPWR VGND VPWR VGND sky130_ef_sc_hd__decap_12
XFILLER_0_2_389 VPWR VGND VPWR VGND sky130_ef_sc_hd__decap_12
XFILLER_0_107_1281 VGND VGND VPWR VPWR sky130_fd_sc_hd__decap_6
XFILLER_0_177_1213 VPWR VGND VPWR VGND sky130_ef_sc_hd__decap_12
XFILLER_0_195_47 VGND VGND VPWR VPWR sky130_fd_sc_hd__fill_1
XFILLER_0_43_1291 VPWR VGND VPWR VGND sky130_ef_sc_hd__decap_12
XFILLER_0_78_1343 VGND VGND VPWR VPWR sky130_fd_sc_hd__fill_1
XFILLER_0_128_41 VGND VGND VPWR VPWR sky130_fd_sc_hd__decap_8
XFILLER_0_177_1279 VPWR VGND VPWR VGND sky130_ef_sc_hd__decap_12
XFILLER_0_223_777 VGND VGND VPWR VPWR sky130_fd_sc_hd__decap_6
XFILLER_0_222_221 VPWR VGND VPWR VGND sky130_ef_sc_hd__decap_12
XFILLER_0_214_1129 VPWR VGND VPWR VGND sky130_ef_sc_hd__decap_12
XFILLER_0_195_629 VPWR VGND VPWR VGND sky130_ef_sc_hd__decap_12
XFILLER_0_222_265 VPWR VGND VPWR VGND sky130_ef_sc_hd__decap_12
XFILLER_0_210_405 VPWR VGND VPWR VGND sky130_ef_sc_hd__decap_12
XFILLER_0_210_449 VPWR VGND VPWR VGND sky130_ef_sc_hd__decap_12
XFILLER_0_93_605 VPWR VGND VPWR VGND sky130_ef_sc_hd__decap_12
XPHY_608 VGND VGND VPWR VPWR sky130_fd_sc_hd__decap_3
XPHY_619 VGND VGND VPWR VPWR sky130_fd_sc_hd__decap_3
XFILLER_0_110_1105 VPWR VGND VPWR VGND sky130_ef_sc_hd__decap_12
XPHY_1207 VGND VGND VPWR VPWR sky130_fd_sc_hd__decap_3
XFILLER_0_188_1331 VGND VGND VPWR VPWR sky130_fd_sc_hd__decap_6
XFILLER_0_114_1285 VGND VGND VPWR VPWR sky130_fd_sc_hd__decap_3
XFILLER_0_11_1213 VPWR VGND VPWR VGND sky130_ef_sc_hd__decap_12
XFILLER_0_50_1251 VPWR VGND VPWR VGND sky130_ef_sc_hd__decap_12
XFILLER_0_110_1149 VPWR VGND VPWR VGND sky130_ef_sc_hd__decap_12
XFILLER_0_50_1295 VPWR VGND VPWR VGND sky130_ef_sc_hd__decap_12
XFILLER_0_85_1303 VGND VGND VPWR VPWR sky130_fd_sc_hd__decap_6
XFILLER_0_184_1239 VPWR VGND VPWR VGND sky130_ef_sc_hd__decap_12
XFILLER_0_2_1093 VPWR VGND VPWR VGND sky130_ef_sc_hd__decap_12
XFILLER_0_11_1279 VPWR VGND VPWR VGND sky130_ef_sc_hd__decap_12
XFILLER_0_225_1225 VGND VGND VPWR VPWR sky130_fd_sc_hd__decap_6
XFILLER_0_5_161 VGND VGND VPWR VPWR sky130_fd_sc_hd__decap_6
XFILLER_0_225_1269 VPWR VGND VPWR VGND sky130_ef_sc_hd__decap_12
XFILLER_0_160_1283 VPWR VGND VPWR VGND sky130_ef_sc_hd__decap_12
XFILLER_0_121_1201 VPWR VGND VPWR VGND sky130_ef_sc_hd__decap_12
XFILLER_0_112_681 VPWR VGND VPWR VGND sky130_ef_sc_hd__decap_12
XFILLER_0_121_1267 VPWR VGND VPWR VGND sky130_ef_sc_hd__decap_12
XFILLER_0_22_1331 VGND VGND VPWR VPWR sky130_fd_sc_hd__decap_6
XFILLER_0_219_1007 VGND VGND VPWR VPWR sky130_fd_sc_hd__fill_1
XFILLER_0_201_1291 VPWR VGND VPWR VGND sky130_ef_sc_hd__decap_12
XFILLER_0_195_1335 VGND VGND VPWR VPWR sky130_fd_sc_hd__decap_8
XFILLER_0_156_1319 VPWR VGND VPWR VGND sky130_ef_sc_hd__decap_12
XFILLER_0_92_1307 VPWR VGND VPWR VGND sky130_ef_sc_hd__decap_12
XFILLER_0_214_755 VGND VGND VPWR VPWR sky130_fd_sc_hd__fill_1
XANTENNA_input122_A w01[14] VGND VGND VPWR VPWR sky130_fd_sc_hd__diode_2
XTAP_2001 VGND VPWR sky130_fd_sc_hd__tapvpwrvgnd_1
XTAP_2023 VGND VPWR sky130_fd_sc_hd__tapvpwrvgnd_1
XTAP_2034 VGND VPWR sky130_fd_sc_hd__tapvpwrvgnd_1
XTAP_2012 VGND VPWR sky130_fd_sc_hd__tapvpwrvgnd_1
XFILLER_0_9_1225 VPWR VGND VPWR VGND sky130_ef_sc_hd__decap_12
XTAP_2067 VGND VPWR sky130_fd_sc_hd__tapvpwrvgnd_1
XTAP_2045 VGND VPWR sky130_fd_sc_hd__tapvpwrvgnd_1
XTAP_1300 VGND VPWR sky130_fd_sc_hd__tapvpwrvgnd_1
XTAP_1322 VGND VPWR sky130_fd_sc_hd__tapvpwrvgnd_1
XFILLER_0_84_605 VPWR VGND VPWR VGND sky130_ef_sc_hd__decap_12
XTAP_1311 VGND VPWR sky130_fd_sc_hd__tapvpwrvgnd_1
XTAP_2056 VGND VPWR sky130_fd_sc_hd__tapvpwrvgnd_1
XTAP_2089 VGND VPWR sky130_fd_sc_hd__tapvpwrvgnd_1
XTAP_1366 VGND VPWR sky130_fd_sc_hd__tapvpwrvgnd_1
XTAP_1344 VGND VPWR sky130_fd_sc_hd__tapvpwrvgnd_1
XTAP_1333 VGND VPWR sky130_fd_sc_hd__tapvpwrvgnd_1
XTAP_1355 VGND VPWR sky130_fd_sc_hd__tapvpwrvgnd_1
XTAP_2078 VGND VPWR sky130_fd_sc_hd__tapvpwrvgnd_1
XTAP_1388 VGND VPWR sky130_fd_sc_hd__tapvpwrvgnd_1
XTAP_1399 VGND VPWR sky130_fd_sc_hd__tapvpwrvgnd_1
XTAP_1377 VGND VPWR sky130_fd_sc_hd__tapvpwrvgnd_1
Xinput28 act_row1_in[5] VGND VGND VPWR VPWR net28 sky130_fd_sc_hd__buf_1
Xinput17 act_row1_in[0] VGND VGND VPWR VPWR net17 sky130_fd_sc_hd__buf_1
Xinput39 psum_col0_in[14] VGND VGND VPWR VPWR net39 sky130_fd_sc_hd__buf_1
XFILLER_0_220_53 VPWR VGND VPWR VGND sky130_ef_sc_hd__decap_12
XFILLER_0_107_497 VGND VGND VPWR VPWR sky130_fd_sc_hd__decap_6
XFILLER_0_220_97 VPWR VGND VPWR VGND sky130_ef_sc_hd__decap_12
XFILLER_0_58_27 VGND VGND VPWR VPWR sky130_fd_sc_hd__fill_1
XFILLER_0_27_1253 VGND VGND VPWR VPWR sky130_fd_sc_hd__fill_1
XFILLER_0_58_49 VGND VGND VPWR VPWR sky130_fd_sc_hd__fill_1
XFILLER_0_100_1307 VPWR VGND VPWR VGND sky130_ef_sc_hd__decap_12
XFILLER_0_74_15 VPWR VGND VPWR VGND sky130_ef_sc_hd__decap_12
XFILLER_0_165_39 VGND VGND VPWR VPWR sky130_fd_sc_hd__decap_8
XFILLER_0_220_725 VPWR VGND VPWR VGND sky130_ef_sc_hd__decap_12
XFILLER_0_220_769 VPWR VGND VPWR VGND sky130_ef_sc_hd__decap_12
XFILLER_0_177_629 VPWR VGND VPWR VGND sky130_ef_sc_hd__decap_12
XFILLER_0_181_27 VPWR VGND VPWR VGND sky130_ef_sc_hd__decap_12
XFILLER_0_75_605 VPWR VGND VPWR VGND sky130_ef_sc_hd__decap_12
XFILLER_0_34_1213 VPWR VGND VPWR VGND sky130_ef_sc_hd__decap_12
XTAP_2590 VGND VPWR sky130_fd_sc_hd__tapvpwrvgnd_1
XFILLER_0_142_3 VPWR VGND VPWR VGND sky130_ef_sc_hd__decap_12
XFILLER_0_90_619 VPWR VGND VPWR VGND sky130_ef_sc_hd__decap_12
XFILLER_0_69_1309 VGND VGND VPWR VPWR sky130_fd_sc_hd__fill_1
XFILLER_0_144_1201 VPWR VGND VPWR VGND sky130_ef_sc_hd__decap_12
XFILLER_0_109_1343 VGND VGND VPWR VPWR sky130_fd_sc_hd__fill_1
XFILLER_0_101_629 VPWR VGND VPWR VGND sky130_ef_sc_hd__decap_12
XFILLER_0_3_665 VGND VGND VPWR VPWR sky130_fd_sc_hd__decap_6
XFILLER_0_2_153 VPWR VGND VPWR VGND sky130_ef_sc_hd__decap_12
XFILLER_0_2_197 VPWR VGND VPWR VGND sky130_ef_sc_hd__decap_12
XFILLER_0_47_3 VPWR VGND VPWR VGND sky130_ef_sc_hd__decap_12
XFILLER_0_208_593 VPWR VGND VPWR VGND sky130_ef_sc_hd__decap_12
XFILLER_0_223_541 VPWR VGND VPWR VGND sky130_ef_sc_hd__decap_12
XFILLER_0_218_1073 VPWR VGND VPWR VGND sky130_ef_sc_hd__decap_12
XFILLER_0_223_585 VPWR VGND VPWR VGND sky130_ef_sc_hd__decap_12
XFILLER_0_151_1249 VGND VGND VPWR VPWR sky130_fd_sc_hd__decap_4
XFILLER_0_66_605 VPWR VGND VPWR VGND sky130_ef_sc_hd__decap_12
XPHY_405 VGND VGND VPWR VPWR sky130_fd_sc_hd__decap_3
XPHY_416 VGND VGND VPWR VPWR sky130_fd_sc_hd__decap_3
XPHY_1004 VGND VGND VPWR VPWR sky130_fd_sc_hd__decap_3
XFILLER_0_109_729 VPWR VGND VPWR VGND sky130_ef_sc_hd__decap_12
XPHY_449 VGND VGND VPWR VPWR sky130_fd_sc_hd__decap_3
XPHY_427 VGND VGND VPWR VPWR sky130_fd_sc_hd__decap_3
XPHY_438 VGND VGND VPWR VPWR sky130_fd_sc_hd__decap_3
XPHY_1026 VGND VGND VPWR VPWR sky130_fd_sc_hd__decap_3
XPHY_1015 VGND VGND VPWR VPWR sky130_fd_sc_hd__decap_3
XPHY_1037 VGND VGND VPWR VPWR sky130_fd_sc_hd__decap_3
XFILLER_0_114_1093 VPWR VGND VPWR VGND sky130_ef_sc_hd__decap_12
XPHY_1048 VGND VGND VPWR VPWR sky130_fd_sc_hd__decap_3
XPHY_1059 VGND VGND VPWR VPWR sky130_fd_sc_hd__decap_3
XFILLER_0_89_1291 VPWR VGND VPWR VGND sky130_ef_sc_hd__decap_12
XFILLER_0_7_993 VPWR VGND VPWR VGND sky130_ef_sc_hd__decap_12
XFILLER_0_225_1033 VPWR VGND VPWR VGND sky130_ef_sc_hd__decap_12
XFILLER_0_104_445 VGND VGND VPWR VPWR sky130_fd_sc_hd__decap_3
XFILLER_0_225_1077 VPWR VGND VPWR VGND sky130_ef_sc_hd__decap_12
XFILLER_0_104_489 VPWR VGND VPWR VGND sky130_ef_sc_hd__decap_12
XFILLER_0_203_1331 VGND VGND VPWR VPWR sky130_fd_sc_hd__fill_2
XFILLER_0_218_357 VGND VGND VPWR VPWR sky130_fd_sc_hd__decap_6
XFILLER_0_96_1251 VPWR VGND VPWR VGND sky130_ef_sc_hd__decap_12
XFILLER_0_57_1213 VPWR VGND VPWR VGND sky130_ef_sc_hd__decap_12
XFILLER_0_96_1295 VPWR VGND VPWR VGND sky130_ef_sc_hd__decap_12
XFILLER_0_44_29 VPWR VGND VPWR VGND sky130_ef_sc_hd__decap_12
XFILLER_0_159_629 VPWR VGND VPWR VGND sky130_ef_sc_hd__decap_12
XFILLER_0_57_1279 VPWR VGND VPWR VGND sky130_ef_sc_hd__decap_12
XFILLER_0_57_605 VPWR VGND VPWR VGND sky130_ef_sc_hd__decap_12
XFILLER_0_210_1313 VGND VGND VPWR VPWR sky130_fd_sc_hd__decap_3
XFILLER_0_182_643 VPWR VGND VPWR VGND sky130_ef_sc_hd__decap_12
XPHY_972 VGND VGND VPWR VPWR sky130_fd_sc_hd__decap_3
XPHY_961 VGND VGND VPWR VPWR sky130_fd_sc_hd__decap_3
XFILLER_0_167_1201 VPWR VGND VPWR VGND sky130_ef_sc_hd__decap_12
XFILLER_0_72_619 VPWR VGND VPWR VGND sky130_ef_sc_hd__decap_12
XPHY_950 VGND VGND VPWR VPWR sky130_fd_sc_hd__decap_3
XPHY_994 VGND VGND VPWR VPWR sky130_fd_sc_hd__decap_3
XPHY_983 VGND VGND VPWR VPWR sky130_fd_sc_hd__decap_3
XFILLER_0_68_1331 VGND VGND VPWR VPWR sky130_fd_sc_hd__decap_6
XFILLER_0_167_1267 VPWR VGND VPWR VGND sky130_ef_sc_hd__decap_12
XFILLER_0_8_29 VPWR VGND VPWR VGND sky130_ef_sc_hd__decap_12
XFILLER_0_107_261 VPWR VGND VPWR VGND sky130_ef_sc_hd__decap_12
XFILLER_0_114_7 VPWR VGND VPWR VGND sky130_ef_sc_hd__decap_12
XFILLER_0_114_209 VPWR VGND VPWR VGND sky130_ef_sc_hd__decap_12
XFILLER_0_69_15 VPWR VGND VPWR VGND sky130_ef_sc_hd__decap_12
XFILLER_0_208_1275 VGND VGND VPWR VPWR sky130_fd_sc_hd__decap_6
XFILLER_0_64_1239 VPWR VGND VPWR VGND sky130_ef_sc_hd__decap_12
XFILLER_0_176_27 VGND VGND VPWR VPWR sky130_fd_sc_hd__fill_1
XFILLER_0_176_49 VGND VGND VPWR VPWR sky130_fd_sc_hd__fill_1
XFILLER_0_104_1273 VPWR VGND VPWR VGND sky130_ef_sc_hd__decap_12
XFILLER_0_85_47 VGND VGND VPWR VPWR sky130_fd_sc_hd__fill_1
XFILLER_0_225_839 VGND VGND VPWR VPWR sky130_fd_sc_hd__fill_1
XFILLER_0_139_1303 VGND VGND VPWR VPWR sky130_fd_sc_hd__decap_6
XFILLER_0_18_41 VGND VGND VPWR VPWR sky130_fd_sc_hd__decap_8
XFILLER_0_40_1283 VPWR VGND VPWR VGND sky130_ef_sc_hd__decap_12
XFILLER_0_174_1227 VPWR VGND VPWR VGND sky130_ef_sc_hd__decap_12
XFILLER_0_215_1213 VPWR VGND VPWR VGND sky130_ef_sc_hd__decap_12
XFILLER_0_75_1335 VGND VGND VPWR VPWR sky130_fd_sc_hd__decap_8
XFILLER_0_215_1257 VPWR VGND VPWR VGND sky130_ef_sc_hd__decap_12
XFILLER_0_220_533 VPWR VGND VPWR VGND sky130_ef_sc_hd__decap_12
XFILLER_0_36_1319 VPWR VGND VPWR VGND sky130_ef_sc_hd__decap_12
XFILLER_0_48_605 VPWR VGND VPWR VGND sky130_ef_sc_hd__decap_12
XFILLER_0_111_1233 VPWR VGND VPWR VGND sky130_ef_sc_hd__decap_12
XFILLER_0_185_1323 VGND VGND VPWR VPWR sky130_fd_sc_hd__decap_8
XFILLER_0_146_1307 VPWR VGND VPWR VGND sky130_ef_sc_hd__decap_12
XFILLER_0_71_641 VGND VGND VPWR VPWR sky130_fd_sc_hd__decap_4
XANTENNA_u_pe01_weight_in[5] net128 VGND VGND VPWR VPWR sky130_fd_sc_hd__diode_2
XFILLER_0_222_1217 VPWR VGND VPWR VGND sky130_ef_sc_hd__decap_12
XFILLER_0_82_1339 VGND VGND VPWR VPWR sky130_fd_sc_hd__decap_4
XFILLER_0_3_473 VPWR VGND VPWR VGND sky130_ef_sc_hd__decap_12
XFILLER_0_110_993 VPWR VGND VPWR VGND sky130_ef_sc_hd__decap_12
XFILLER_0_215_305 VPWR VGND VPWR VGND sky130_ef_sc_hd__decap_12
XFILLER_0_215_349 VPWR VGND VPWR VGND sky130_ef_sc_hd__decap_12
XFILLER_0_224_861 VGND VGND VPWR VPWR sky130_fd_sc_hd__decap_6
XFILLER_0_223_393 VPWR VGND VPWR VGND sky130_ef_sc_hd__decap_12
XFILLER_0_39_605 VPWR VGND VPWR VGND sky130_ef_sc_hd__decap_12
XFILLER_0_6_1217 VPWR VGND VPWR VGND sky130_ef_sc_hd__decap_12
XPHY_202 VGND VGND VPWR VPWR sky130_fd_sc_hd__decap_3
XPHY_213 VGND VGND VPWR VPWR sky130_fd_sc_hd__decap_3
XPHY_224 VGND VGND VPWR VPWR sky130_fd_sc_hd__decap_3
XPHY_268 VGND VGND VPWR VPWR sky130_fd_sc_hd__decap_3
XPHY_257 VGND VGND VPWR VPWR sky130_fd_sc_hd__decap_3
XPHY_246 VGND VGND VPWR VPWR sky130_fd_sc_hd__decap_3
XPHY_235 VGND VGND VPWR VPWR sky130_fd_sc_hd__decap_3
XFILLER_0_54_619 VPWR VGND VPWR VGND sky130_ef_sc_hd__decap_12
XFILLER_0_164_643 VPWR VGND VPWR VGND sky130_ef_sc_hd__decap_12
XFILLER_0_109_559 VGND VGND VPWR VPWR sky130_fd_sc_hd__fill_1
XPHY_279 VGND VGND VPWR VPWR sky130_fd_sc_hd__decap_3
XFILLER_0_105_721 VGND VGND VPWR VPWR sky130_fd_sc_hd__decap_6
XFILLER_0_105_765 VPWR VGND VPWR VGND sky130_ef_sc_hd__decap_12
XFILLER_0_104_253 VPWR VGND VPWR VGND sky130_ef_sc_hd__decap_12
XFILLER_0_24_1201 VPWR VGND VPWR VGND sky130_ef_sc_hd__decap_12
XANTENNA_input50_A psum_col0_in[24] VGND VGND VPWR VPWR sky130_fd_sc_hd__diode_2
XFILLER_0_30_593 VPWR VGND VPWR VGND sky130_ef_sc_hd__decap_12
XFILLER_0_197_1249 VGND VGND VPWR VPWR sky130_fd_sc_hd__decap_4
XFILLER_0_218_121 VPWR VGND VPWR VGND sky130_ef_sc_hd__decap_12
XFILLER_0_218_165 VPWR VGND VPWR VGND sky130_ef_sc_hd__decap_12
XFILLER_0_55_39 VGND VGND VPWR VPWR sky130_fd_sc_hd__decap_8
XFILLER_0_226_41 VGND VGND VPWR VPWR sky130_fd_sc_hd__decap_4
XFILLER_0_226_85 VGND VGND VPWR VPWR sky130_fd_sc_hd__decap_4
XFILLER_0_71_27 VPWR VGND VPWR VGND sky130_ef_sc_hd__decap_12
XFILLER_0_162_29 VPWR VGND VPWR VGND sky130_ef_sc_hd__decap_12
XFILLER_0_97_593 VPWR VGND VPWR VGND sky130_ef_sc_hd__decap_12
XFILLER_0_210_1121 VPWR VGND VPWR VGND sky130_ef_sc_hd__decap_12
XFILLER_0_210_1165 VGND VGND VPWR VPWR sky130_fd_sc_hd__decap_8
XPHY_780 VGND VGND VPWR VPWR sky130_fd_sc_hd__decap_3
XFILLER_0_31_1249 VGND VGND VPWR VPWR sky130_fd_sc_hd__decap_4
XPHY_791 VGND VGND VPWR VPWR sky130_fd_sc_hd__decap_3
XFILLER_0_5_727 VGND VGND VPWR VPWR sky130_fd_sc_hd__fill_1
XFILLER_0_53_641 VGND VGND VPWR VPWR sky130_fd_sc_hd__decap_4
XFILLER_0_108_581 VGND VGND VPWR VPWR sky130_fd_sc_hd__decap_6
XFILLER_0_111_55 VGND VGND VPWR VPWR sky130_fd_sc_hd__fill_1
XFILLER_0_187_15 VPWR VGND VPWR VGND sky130_ef_sc_hd__decap_12
XANTENNA_u_pe00_valid_in net99 VGND VGND VPWR VPWR sky130_fd_sc_hd__diode_2
XFILLER_0_180_1275 VGND VGND VPWR VPWR sky130_fd_sc_hd__decap_6
XFILLER_0_1_933 VPWR VGND VPWR VGND sky130_ef_sc_hd__decap_12
XFILLER_0_141_1237 VPWR VGND VPWR VGND sky130_ef_sc_hd__decap_12
XFILLER_0_1_977 VPWR VGND VPWR VGND sky130_ef_sc_hd__decap_12
XFILLER_0_110_245 VGND VGND VPWR VPWR sky130_fd_sc_hd__decap_6
XFILLER_0_21_593 VPWR VGND VPWR VGND sky130_ef_sc_hd__decap_12
XFILLER_0_110_289 VPWR VGND VPWR VGND sky130_ef_sc_hd__decap_12
XFILLER_0_213_809 VPWR VGND VPWR VGND sky130_ef_sc_hd__decap_12
XFILLER_0_136_41 VGND VGND VPWR VPWR sky130_fd_sc_hd__decap_8
XFILLER_0_215_1021 VPWR VGND VPWR VGND sky130_ef_sc_hd__decap_12
XFILLER_0_215_1065 VPWR VGND VPWR VGND sky130_ef_sc_hd__decap_12
XFILLER_0_221_853 VPWR VGND VPWR VGND sky130_ef_sc_hd__decap_12
XFILLER_0_221_897 VPWR VGND VPWR VGND sky130_ef_sc_hd__decap_12
XFILLER_0_220_363 VGND VGND VPWR VPWR sky130_fd_sc_hd__fill_1
XFILLER_0_88_593 VPWR VGND VPWR VGND sky130_ef_sc_hd__decap_12
XFILLER_0_0_85 VGND VGND VPWR VPWR sky130_fd_sc_hd__decap_6
XFILLER_0_36_619 VPWR VGND VPWR VGND sky130_ef_sc_hd__decap_12
XFILLER_0_111_1063 VGND VGND VPWR VPWR sky130_fd_sc_hd__fill_1
XFILLER_0_146_643 VPWR VGND VPWR VGND sky130_ef_sc_hd__decap_12
XFILLER_0_1_1169 VGND VGND VPWR VPWR sky130_fd_sc_hd__decap_6
XFILLER_0_47_1201 VPWR VGND VPWR VGND sky130_ef_sc_hd__decap_12
XFILLER_0_86_1283 VPWR VGND VPWR VGND sky130_ef_sc_hd__decap_12
XFILLER_0_226_1194 VGND VGND VPWR VPWR sky130_fd_sc_hd__fill_2
XFILLER_0_226_1183 VGND VGND VPWR VPWR sky130_fd_sc_hd__fill_1
XFILLER_0_226_1172 VGND VGND VPWR VPWR sky130_fd_sc_hd__fill_2
XFILLER_0_114_573 VPWR VGND VPWR VGND sky130_ef_sc_hd__decap_12
XFILLER_0_3_281 VPWR VGND VPWR VGND sky130_ef_sc_hd__decap_12
XFILLER_0_4_793 VPWR VGND VPWR VGND sky130_ef_sc_hd__decap_12
XFILLER_0_47_1267 VPWR VGND VPWR VGND sky130_ef_sc_hd__decap_12
XFILLER_0_12_593 VPWR VGND VPWR VGND sky130_ef_sc_hd__decap_12
Xclkbuf_1_1__f_clk clknet_0_clk VGND VGND VPWR VPWR clknet_1_1__leaf_clk sky130_fd_sc_hd__clkbuf_16
XFILLER_0_216_625 VPWR VGND VPWR VGND sky130_ef_sc_hd__decap_12
XFILLER_0_216_669 VPWR VGND VPWR VGND sky130_ef_sc_hd__decap_12
XFILLER_0_215_113 VPWR VGND VPWR VGND sky130_ef_sc_hd__decap_12
XFILLER_0_157_1255 VPWR VGND VPWR VGND sky130_ef_sc_hd__decap_12
XFILLER_0_118_1239 VPWR VGND VPWR VGND sky130_ef_sc_hd__decap_12
XFILLER_0_19_1303 VGND VGND VPWR VPWR sky130_fd_sc_hd__decap_6
XFILLER_0_54_1227 VPWR VGND VPWR VGND sky130_ef_sc_hd__decap_12
XFILLER_0_211_385 VGND VGND VPWR VPWR sky130_fd_sc_hd__decap_6
XFILLER_0_79_593 VPWR VGND VPWR VGND sky130_ef_sc_hd__decap_12
XFILLER_0_212_65 VPWR VGND VPWR VGND sky130_ef_sc_hd__decap_12
XANTENNA_u_pe01_act_in[1] act_00_out_01_in\[1\] VGND VGND VPWR VPWR sky130_fd_sc_hd__diode_2
XFILLER_0_35_641 VGND VGND VPWR VPWR sky130_fd_sc_hd__decap_4
XANTENNA_input98_A rst_n VGND VGND VPWR VPWR sky130_fd_sc_hd__diode_2
XFILLER_0_129_1335 VGND VGND VPWR VPWR sky130_fd_sc_hd__decap_8
XFILLER_0_205_1201 VPWR VGND VPWR VGND sky130_ef_sc_hd__decap_12
XFILLER_0_65_1323 VPWR VGND VPWR VGND sky130_ef_sc_hd__decap_12
XFILLER_0_105_573 VPWR VGND VPWR VGND sky130_ef_sc_hd__decap_12
XFILLER_0_50_655 VGND VGND VPWR VPWR sky130_fd_sc_hd__decap_4
XFILLER_0_26_1307 VPWR VGND VPWR VGND sky130_ef_sc_hd__decap_12
XFILLER_0_205_1267 VPWR VGND VPWR VGND sky130_ef_sc_hd__decap_12
XFILLER_0_219_441 VGND VGND VPWR VPWR sky130_fd_sc_hd__decap_6
XFILLER_0_219_485 VPWR VGND VPWR VGND sky130_ef_sc_hd__decap_12
XFILLER_0_140_1281 VGND VGND VPWR VPWR sky130_fd_sc_hd__fill_1
XFILLER_0_66_49 VGND VGND VPWR VPWR sky130_fd_sc_hd__fill_1
XFILLER_0_175_1311 VPWR VGND VPWR VGND sky130_ef_sc_hd__decap_12
XFILLER_0_207_647 VPWR VGND VPWR VGND sky130_ef_sc_hd__decap_12
XFILLER_0_221_105 VGND VGND VPWR VPWR sky130_fd_sc_hd__decap_6
XFILLER_0_136_1339 VGND VGND VPWR VPWR sky130_fd_sc_hd__decap_4
XFILLER_0_82_15 VPWR VGND VPWR VGND sky130_ef_sc_hd__decap_12
XFILLER_0_173_39 VGND VGND VPWR VPWR sky130_fd_sc_hd__decap_8
XFILLER_0_216_1341 VGND VGND VPWR VPWR sky130_fd_sc_hd__decap_3
XFILLER_0_212_1205 VPWR VGND VPWR VGND sky130_ef_sc_hd__decap_12
XFILLER_0_221_149 VPWR VGND VPWR VGND sky130_ef_sc_hd__decap_12
XFILLER_0_106_77 VGND VGND VPWR VPWR sky130_fd_sc_hd__decap_6
XFILLER_0_222_3 VPWR VGND VPWR VGND sky130_ef_sc_hd__decap_12
XFILLER_0_128_643 VPWR VGND VPWR VGND sky130_ef_sc_hd__decap_12
XFILLER_0_18_619 VPWR VGND VPWR VGND sky130_ef_sc_hd__decap_12
XFILLER_0_122_10 VPWR VGND VPWR VGND sky130_ef_sc_hd__decap_12
XFILLER_0_182_1337 VGND VGND VPWR VPWR sky130_fd_sc_hd__fill_1
XFILLER_0_223_1301 VPWR VGND VPWR VGND sky130_ef_sc_hd__decap_12
XFILLER_0_41_655 VGND VGND VPWR VPWR sky130_fd_sc_hd__fill_2
XFILLER_0_1_741 VPWR VGND VPWR VGND sky130_ef_sc_hd__decap_12
XFILLER_0_1_785 VPWR VGND VPWR VGND sky130_ef_sc_hd__decap_12
XFILLER_0_0_273 VGND VGND VPWR VPWR sky130_fd_sc_hd__decap_6
XFILLER_0_0_251 VGND VGND VPWR VPWR sky130_fd_sc_hd__fill_1
XFILLER_0_226_934 VPWR VGND VPWR VGND sky130_ef_sc_hd__decap_12
XFILLER_0_0_295 VPWR VGND VPWR VGND sky130_ef_sc_hd__decap_12
XFILLER_0_226_989 VGND VGND VPWR VPWR sky130_fd_sc_hd__fill_2
XFILLER_0_213_617 VPWR VGND VPWR VGND sky130_ef_sc_hd__decap_12
XFILLER_0_77_1249 VGND VGND VPWR VPWR sky130_fd_sc_hd__decap_4
XTAP_2408 VGND VPWR sky130_fd_sc_hd__tapvpwrvgnd_1
XTAP_2419 VGND VPWR sky130_fd_sc_hd__tapvpwrvgnd_1
XFILLER_0_7_1301 VPWR VGND VPWR VGND sky130_ef_sc_hd__decap_12
XANTENNA_u_pe10_load_weight net33 VGND VGND VPWR VPWR sky130_fd_sc_hd__diode_2
XTAP_1718 VGND VPWR sky130_fd_sc_hd__tapvpwrvgnd_1
XTAP_1707 VGND VPWR sky130_fd_sc_hd__tapvpwrvgnd_1
XTAP_1729 VGND VPWR sky130_fd_sc_hd__tapvpwrvgnd_1
XFILLER_0_187_1237 VPWR VGND VPWR VGND sky130_ef_sc_hd__decap_12
XFILLER_0_113_1169 VGND VGND VPWR VPWR sky130_fd_sc_hd__decap_6
XFILLER_0_17_641 VGND VGND VPWR VPWR sky130_fd_sc_hd__decap_4
XFILLER_0_32_655 VGND VGND VPWR VPWR sky130_fd_sc_hd__decap_4
XANTENNA_input152_A w11[12] VGND VGND VPWR VPWR sky130_fd_sc_hd__diode_2
XFILLER_0_60_1275 VGND VGND VPWR VPWR sky130_fd_sc_hd__decap_6
XFILLER_0_217_945 VGND VGND VPWR VPWR sky130_fd_sc_hd__decap_6
XFILLER_0_216_433 VPWR VGND VPWR VGND sky130_ef_sc_hd__decap_12
XFILLER_0_21_1237 VPWR VGND VPWR VGND sky130_ef_sc_hd__decap_12
XFILLER_0_217_989 VPWR VGND VPWR VGND sky130_ef_sc_hd__decap_12
XFILLER_0_204_617 VGND VGND VPWR VPWR sky130_fd_sc_hd__fill_1
XFILLER_0_216_477 VPWR VGND VPWR VGND sky130_ef_sc_hd__decap_12
XTAP_2931 VGND VPWR sky130_fd_sc_hd__tapvpwrvgnd_1
XTAP_2920 VGND VPWR sky130_fd_sc_hd__tapvpwrvgnd_1
XANTENNA_input13_A act_row0_in[6] VGND VGND VPWR VPWR sky130_fd_sc_hd__diode_2
XTAP_2964 VGND VPWR sky130_fd_sc_hd__tapvpwrvgnd_1
XTAP_2953 VGND VPWR sky130_fd_sc_hd__tapvpwrvgnd_1
XTAP_2942 VGND VPWR sky130_fd_sc_hd__tapvpwrvgnd_1
XFILLER_0_52_29 VPWR VGND VPWR VGND sky130_ef_sc_hd__decap_12
XFILLER_0_211_193 VPWR VGND VPWR VGND sky130_ef_sc_hd__decap_12
XFILLER_0_170_1263 VPWR VGND VPWR VGND sky130_ef_sc_hd__decap_12
XFILLER_0_131_1225 VPWR VGND VPWR VGND sky130_ef_sc_hd__decap_12
XFILLER_0_140_605 VPWR VGND VPWR VGND sky130_ef_sc_hd__decap_12
XFILLER_0_112_307 VGND VGND VPWR VPWR sky130_fd_sc_hd__fill_1
XFILLER_0_106_893 VPWR VGND VPWR VGND sky130_ef_sc_hd__decap_12
XFILLER_0_23_655 VGND VGND VPWR VPWR sky130_fd_sc_hd__fill_2
XFILLER_0_142_1343 VGND VGND VPWR VPWR sky130_fd_sc_hd__fill_1
XFILLER_0_219_293 VPWR VGND VPWR VGND sky130_ef_sc_hd__decap_12
XFILLER_0_184_27 VGND VGND VPWR VPWR sky130_fd_sc_hd__fill_1
XFILLER_0_184_49 VGND VGND VPWR VPWR sky130_fd_sc_hd__fill_1
XFILLER_0_93_47 VGND VGND VPWR VPWR sky130_fd_sc_hd__decap_3
XFILLER_0_172_3 VPWR VGND VPWR VGND sky130_ef_sc_hd__decap_12
XFILLER_0_26_41 VGND VGND VPWR VPWR sky130_fd_sc_hd__decap_8
XFILLER_0_222_469 VGND VGND VPWR VPWR sky130_fd_sc_hd__decap_6
XFILLER_0_37_1255 VPWR VGND VPWR VGND sky130_ef_sc_hd__decap_12
XFILLER_0_212_1035 VGND VGND VPWR VPWR sky130_fd_sc_hd__fill_1
XFILLER_0_110_1309 VGND VGND VPWR VPWR sky130_fd_sc_hd__decap_6
XFILLER_0_6_811 VGND VGND VPWR VPWR sky130_fd_sc_hd__fill_1
XFILLER_0_2_1253 VGND VGND VPWR VPWR sky130_fd_sc_hd__decap_6
XFILLER_0_186_1281 VGND VGND VPWR VPWR sky130_fd_sc_hd__fill_1
XFILLER_0_108_1205 VPWR VGND VPWR VGND sky130_ef_sc_hd__decap_12
XFILLER_0_131_605 VPWR VGND VPWR VGND sky130_ef_sc_hd__decap_12
XFILLER_0_2_1297 VPWR VGND VPWR VGND sky130_ef_sc_hd__decap_12
XFILLER_0_14_655 VGND VGND VPWR VPWR sky130_fd_sc_hd__decap_4
XFILLER_0_83_1253 VGND VGND VPWR VPWR sky130_fd_sc_hd__fill_1
XANTENNA_u_pe01_psum_in[17] net74 VGND VGND VPWR VPWR sky130_fd_sc_hd__diode_2
XFILLER_0_223_1175 VGND VGND VPWR VPWR sky130_fd_sc_hd__fill_1
XFILLER_0_111_373 VPWR VGND VPWR VGND sky130_ef_sc_hd__decap_12
XANTENNA_input5_A act_row0_in[13] VGND VGND VPWR VPWR sky130_fd_sc_hd__diode_2
XFILLER_0_214_937 VPWR VGND VPWR VGND sky130_ef_sc_hd__decap_12
XFILLER_0_198_605 VPWR VGND VPWR VGND sky130_ef_sc_hd__decap_12
XFILLER_0_119_1323 VPWR VGND VPWR VGND sky130_ef_sc_hd__decap_12
XFILLER_0_20_1281 VGND VGND VPWR VPWR sky130_fd_sc_hd__fill_1
XFILLER_0_213_447 VGND VGND VPWR VPWR sky130_fd_sc_hd__fill_1
XFILLER_0_154_1225 VGND VGND VPWR VPWR sky130_fd_sc_hd__fill_1
XTAP_2216 VGND VPWR sky130_fd_sc_hd__tapvpwrvgnd_1
XTAP_2205 VGND VPWR sky130_fd_sc_hd__tapvpwrvgnd_1
XFILLER_0_90_1213 VPWR VGND VPWR VGND sky130_ef_sc_hd__decap_12
XFILLER_0_55_1311 VPWR VGND VPWR VGND sky130_ef_sc_hd__decap_12
XFILLER_0_222_981 VPWR VGND VPWR VGND sky130_ef_sc_hd__decap_12
XTAP_2227 VGND VPWR sky130_fd_sc_hd__tapvpwrvgnd_1
XTAP_2238 VGND VPWR sky130_fd_sc_hd__tapvpwrvgnd_1
XPHY_22 VGND VGND VPWR VPWR sky130_fd_sc_hd__decap_3
XPHY_11 VGND VGND VPWR VPWR sky130_fd_sc_hd__decap_3
XTAP_1504 VGND VPWR sky130_fd_sc_hd__tapvpwrvgnd_1
XTAP_1515 VGND VPWR sky130_fd_sc_hd__tapvpwrvgnd_1
XTAP_2249 VGND VPWR sky130_fd_sc_hd__tapvpwrvgnd_1
XPHY_55 VGND VGND VPWR VPWR sky130_fd_sc_hd__decap_3
XTAP_1526 VGND VPWR sky130_fd_sc_hd__tapvpwrvgnd_1
XPHY_33 VGND VGND VPWR VPWR sky130_fd_sc_hd__decap_3
XPHY_44 VGND VGND VPWR VPWR sky130_fd_sc_hd__decap_3
XFILLER_0_16_1339 VGND VGND VPWR VPWR sky130_fd_sc_hd__decap_3
XTAP_1537 VGND VPWR sky130_fd_sc_hd__tapvpwrvgnd_1
XTAP_1548 VGND VPWR sky130_fd_sc_hd__tapvpwrvgnd_1
XPHY_88 VGND VGND VPWR VPWR sky130_fd_sc_hd__decap_3
XPHY_77 VGND VGND VPWR VPWR sky130_fd_sc_hd__decap_3
XPHY_66 VGND VGND VPWR VPWR sky130_fd_sc_hd__decap_3
XTAP_1559 VGND VPWR sky130_fd_sc_hd__tapvpwrvgnd_1
XPHY_99 VGND VGND VPWR VPWR sky130_fd_sc_hd__decap_3
XFILLER_0_165_1343 VGND VGND VPWR VPWR sky130_fd_sc_hd__fill_1
XFILLER_0_122_605 VPWR VGND VPWR VGND sky130_ef_sc_hd__decap_12
XFILLER_0_106_189 VGND VGND VPWR VPWR sky130_fd_sc_hd__decap_6
XFILLER_0_62_1337 VGND VGND VPWR VPWR sky130_fd_sc_hd__fill_1
XFILLER_0_217_753 VPWR VGND VPWR VGND sky130_ef_sc_hd__decap_12
XFILLER_0_218_53 VPWR VGND VPWR VGND sky130_ef_sc_hd__decap_12
XFILLER_0_217_797 VPWR VGND VPWR VGND sky130_ef_sc_hd__decap_12
XFILLER_0_189_605 VPWR VGND VPWR VGND sky130_ef_sc_hd__decap_12
XFILLER_0_218_97 VPWR VGND VPWR VGND sky130_ef_sc_hd__decap_12
XFILLER_0_133_1309 VGND VGND VPWR VPWR sky130_fd_sc_hd__fill_1
XFILLER_0_87_647 VPWR VGND VPWR VGND sky130_ef_sc_hd__decap_12
XANTENNA_output217_A net217 VGND VGND VPWR VPWR sky130_fd_sc_hd__diode_2
XTAP_2750 VGND VPWR sky130_fd_sc_hd__tapvpwrvgnd_1
XTAP_2772 VGND VPWR sky130_fd_sc_hd__tapvpwrvgnd_1
XFILLER_0_200_631 VPWR VGND VPWR VGND sky130_ef_sc_hd__decap_12
XTAP_2761 VGND VPWR sky130_fd_sc_hd__tapvpwrvgnd_1
XTAP_2794 VGND VPWR sky130_fd_sc_hd__tapvpwrvgnd_1
XTAP_2783 VGND VPWR sky130_fd_sc_hd__tapvpwrvgnd_1
XFILLER_0_170_29 VPWR VGND VPWR VGND sky130_ef_sc_hd__decap_12
XFILLER_0_67_1237 VPWR VGND VPWR VGND sky130_ef_sc_hd__decap_12
XFILLER_0_180_593 VPWR VGND VPWR VGND sky130_ef_sc_hd__decap_12
XFILLER_0_179_27 VPWR VGND VPWR VGND sky130_ef_sc_hd__decap_12
XFILLER_0_2_357 VGND VGND VPWR VPWR sky130_fd_sc_hd__decap_6
XFILLER_0_220_1315 VGND VGND VPWR VPWR sky130_fd_sc_hd__fill_1
XFILLER_0_11_647 VPWR VGND VPWR VGND sky130_ef_sc_hd__decap_12
XFILLER_0_195_15 VPWR VGND VPWR VGND sky130_ef_sc_hd__decap_12
XFILLER_0_177_1225 VPWR VGND VPWR VGND sky130_ef_sc_hd__decap_12
XFILLER_0_222_233 VPWR VGND VPWR VGND sky130_ef_sc_hd__decap_12
XFILLER_0_222_277 VPWR VGND VPWR VGND sky130_ef_sc_hd__decap_12
XFILLER_0_210_417 VGND VGND VPWR VPWR sky130_fd_sc_hd__decap_3
XFILLER_0_144_41 VGND VGND VPWR VPWR sky130_fd_sc_hd__decap_8
XFILLER_0_153_1291 VPWR VGND VPWR VGND sky130_ef_sc_hd__decap_12
XPHY_609 VGND VGND VPWR VPWR sky130_fd_sc_hd__decap_3
XFILLER_0_93_617 VPWR VGND VPWR VGND sky130_ef_sc_hd__decap_12
XFILLER_0_4_1315 VGND VGND VPWR VPWR sky130_fd_sc_hd__fill_1
XFILLER_0_188_1343 VGND VGND VPWR VPWR sky130_fd_sc_hd__fill_1
XPHY_1208 VGND VGND VPWR VPWR sky130_fd_sc_hd__decap_3
XFILLER_0_110_1117 VPWR VGND VPWR VGND sky130_ef_sc_hd__decap_12
XFILLER_0_50_1263 VPWR VGND VPWR VGND sky130_ef_sc_hd__decap_12
XFILLER_0_11_1225 VPWR VGND VPWR VGND sky130_ef_sc_hd__decap_12
XFILLER_0_2_1061 VPWR VGND VPWR VGND sky130_ef_sc_hd__decap_12
XFILLER_0_108_1035 VGND VGND VPWR VPWR sky130_fd_sc_hd__fill_1
XFILLER_0_171_593 VPWR VGND VPWR VGND sky130_ef_sc_hd__decap_12
XFILLER_0_160_1251 VPWR VGND VPWR VGND sky130_ef_sc_hd__decap_12
XFILLER_0_121_1213 VPWR VGND VPWR VGND sky130_ef_sc_hd__decap_12
XFILLER_0_112_693 VGND VGND VPWR VPWR sky130_fd_sc_hd__decap_6
XFILLER_0_111_181 VPWR VGND VPWR VGND sky130_ef_sc_hd__decap_12
XFILLER_0_195_1303 VGND VGND VPWR VPWR sky130_fd_sc_hd__decap_6
XFILLER_0_160_1295 VPWR VGND VPWR VGND sky130_ef_sc_hd__decap_12
XFILLER_0_22_1343 VGND VGND VPWR VPWR sky130_fd_sc_hd__fill_1
XFILLER_0_121_1279 VPWR VGND VPWR VGND sky130_ef_sc_hd__decap_12
XFILLER_0_226_561 VPWR VGND VPWR VGND sky130_ef_sc_hd__decap_12
XFILLER_0_214_701 VPWR VGND VPWR VGND sky130_ef_sc_hd__decap_12
XFILLER_0_92_1319 VPWR VGND VPWR VGND sky130_ef_sc_hd__decap_12
XFILLER_0_186_619 VPWR VGND VPWR VGND sky130_ef_sc_hd__decap_12
XTAP_2024 VGND VPWR sky130_fd_sc_hd__tapvpwrvgnd_1
XTAP_2013 VGND VPWR sky130_fd_sc_hd__tapvpwrvgnd_1
XFILLER_0_9_1237 VPWR VGND VPWR VGND sky130_ef_sc_hd__decap_12
XTAP_2002 VGND VPWR sky130_fd_sc_hd__tapvpwrvgnd_1
XFILLER_0_210_940 VPWR VGND VPWR VGND sky130_ef_sc_hd__decap_12
XTAP_2068 VGND VPWR sky130_fd_sc_hd__tapvpwrvgnd_1
XTAP_2046 VGND VPWR sky130_fd_sc_hd__tapvpwrvgnd_1
XTAP_2035 VGND VPWR sky130_fd_sc_hd__tapvpwrvgnd_1
XTAP_2057 VGND VPWR sky130_fd_sc_hd__tapvpwrvgnd_1
XTAP_1301 VGND VPWR sky130_fd_sc_hd__tapvpwrvgnd_1
XTAP_1323 VGND VPWR sky130_fd_sc_hd__tapvpwrvgnd_1
XTAP_1312 VGND VPWR sky130_fd_sc_hd__tapvpwrvgnd_1
XFILLER_0_69_647 VGND VGND VPWR VPWR sky130_fd_sc_hd__decap_8
XANTENNA_input115_A w00[8] VGND VGND VPWR VPWR sky130_fd_sc_hd__diode_2
XFILLER_0_132_1331 VGND VGND VPWR VPWR sky130_fd_sc_hd__decap_6
XTAP_1345 VGND VPWR sky130_fd_sc_hd__tapvpwrvgnd_1
XFILLER_0_84_617 VGND VGND VPWR VPWR sky130_fd_sc_hd__fill_1
XTAP_1334 VGND VPWR sky130_fd_sc_hd__tapvpwrvgnd_1
XTAP_1356 VGND VPWR sky130_fd_sc_hd__tapvpwrvgnd_1
XTAP_2079 VGND VPWR sky130_fd_sc_hd__tapvpwrvgnd_1
XTAP_1389 VGND VPWR sky130_fd_sc_hd__tapvpwrvgnd_1
XTAP_1367 VGND VPWR sky130_fd_sc_hd__tapvpwrvgnd_1
XTAP_1378 VGND VPWR sky130_fd_sc_hd__tapvpwrvgnd_1
XANTENNA_input80_A psum_col1_in[22] VGND VGND VPWR VPWR sky130_fd_sc_hd__diode_2
Xinput18 act_row1_in[10] VGND VGND VPWR VPWR net18 sky130_fd_sc_hd__buf_1
Xinput29 act_row1_in[6] VGND VGND VPWR VPWR net29 sky130_fd_sc_hd__buf_1
XFILLER_0_220_65 VPWR VGND VPWR VGND sky130_ef_sc_hd__decap_12
XFILLER_0_162_593 VPWR VGND VPWR VGND sky130_ef_sc_hd__decap_12
XFILLER_0_66_1281 VGND VGND VPWR VPWR sky130_fd_sc_hd__fill_1
XFILLER_0_0_839 VGND VGND VPWR VPWR sky130_fd_sc_hd__fill_1
XFILLER_0_100_1319 VPWR VGND VPWR VGND sky130_ef_sc_hd__decap_12
XFILLER_0_217_561 VPWR VGND VPWR VGND sky130_ef_sc_hd__decap_12
XFILLER_0_74_49 VGND VGND VPWR VPWR sky130_fd_sc_hd__fill_1
XFILLER_0_74_27 VGND VGND VPWR VPWR sky130_fd_sc_hd__fill_1
XFILLER_0_137_1253 VGND VGND VPWR VPWR sky130_fd_sc_hd__fill_1
XFILLER_0_220_737 VPWR VGND VPWR VGND sky130_ef_sc_hd__decap_12
XFILLER_0_181_39 VGND VGND VPWR VPWR sky130_fd_sc_hd__decap_8
XFILLER_0_90_15 VPWR VGND VPWR VGND sky130_ef_sc_hd__decap_12
XTAP_2580 VGND VPWR sky130_fd_sc_hd__tapvpwrvgnd_1
XFILLER_0_185_641 VGND VGND VPWR VPWR sky130_fd_sc_hd__decap_4
XFILLER_0_75_617 VPWR VGND VPWR VGND sky130_ef_sc_hd__decap_12
XFILLER_0_34_1225 VGND VGND VPWR VPWR sky130_fd_sc_hd__fill_1
XTAP_2591 VGND VPWR sky130_fd_sc_hd__tapvpwrvgnd_1
XFILLER_0_7_405 VPWR VGND VPWR VGND sky130_ef_sc_hd__decap_12
XFILLER_0_135_3 VPWR VGND VPWR VGND sky130_ef_sc_hd__decap_12
XFILLER_0_7_449 VPWR VGND VPWR VGND sky130_ef_sc_hd__decap_12
XTAP_1890 VGND VPWR sky130_fd_sc_hd__tapvpwrvgnd_1
XFILLER_0_114_925 VPWR VGND VPWR VGND sky130_ef_sc_hd__decap_12
XFILLER_0_144_1213 VPWR VGND VPWR VGND sky130_ef_sc_hd__decap_12
XFILLER_0_153_593 VPWR VGND VPWR VGND sky130_ef_sc_hd__decap_12
XFILLER_0_2_121 VPWR VGND VPWR VGND sky130_ef_sc_hd__decap_12
XFILLER_0_2_165 VPWR VGND VPWR VGND sky130_ef_sc_hd__decap_12
XFILLER_0_45_1343 VGND VGND VPWR VPWR sky130_fd_sc_hd__fill_1
XFILLER_0_80_1201 VPWR VGND VPWR VGND sky130_ef_sc_hd__decap_12
XFILLER_0_179_1309 VGND VGND VPWR VPWR sky130_fd_sc_hd__fill_1
XFILLER_0_223_553 VGND VGND VPWR VPWR sky130_fd_sc_hd__decap_6
XFILLER_0_218_1085 VGND VGND VPWR VPWR sky130_fd_sc_hd__decap_6
XFILLER_0_223_597 VPWR VGND VPWR VGND sky130_ef_sc_hd__decap_12
XFILLER_0_210_225 VPWR VGND VPWR VGND sky130_ef_sc_hd__decap_12
XFILLER_0_116_1337 VGND VGND VPWR VPWR sky130_fd_sc_hd__fill_1
XFILLER_0_168_619 VPWR VGND VPWR VGND sky130_ef_sc_hd__decap_12
XPHY_406 VGND VGND VPWR VPWR sky130_fd_sc_hd__decap_3
XFILLER_0_66_617 VGND VGND VPWR VPWR sky130_fd_sc_hd__fill_1
XPHY_417 VGND VGND VPWR VPWR sky130_fd_sc_hd__decap_3
XPHY_1005 VGND VGND VPWR VPWR sky130_fd_sc_hd__decap_3
XFILLER_0_114_1061 VGND VGND VPWR VPWR sky130_fd_sc_hd__decap_3
XPHY_439 VGND VGND VPWR VPWR sky130_fd_sc_hd__decap_3
XFILLER_0_8_1281 VGND VGND VPWR VPWR sky130_fd_sc_hd__fill_1
XFILLER_0_13_1309 VGND VGND VPWR VPWR sky130_fd_sc_hd__fill_1
XPHY_428 VGND VGND VPWR VPWR sky130_fd_sc_hd__decap_3
XPHY_1027 VGND VGND VPWR VPWR sky130_fd_sc_hd__decap_3
XPHY_1038 VGND VGND VPWR VPWR sky130_fd_sc_hd__decap_3
XPHY_1016 VGND VGND VPWR VPWR sky130_fd_sc_hd__decap_3
XFILLER_0_0_1009 VGND VGND VPWR VPWR sky130_fd_sc_hd__decap_6
XPHY_1049 VGND VGND VPWR VPWR sky130_fd_sc_hd__decap_3
XFILLER_0_225_1001 VGND VGND VPWR VPWR sky130_fd_sc_hd__decap_6
XFILLER_0_104_413 VGND VGND VPWR VPWR sky130_fd_sc_hd__fill_2
XFILLER_0_225_1045 VPWR VGND VPWR VGND sky130_ef_sc_hd__decap_12
XFILLER_0_144_593 VPWR VGND VPWR VGND sky130_ef_sc_hd__decap_12
XFILLER_0_225_1089 VPWR VGND VPWR VGND sky130_ef_sc_hd__decap_12
XFILLER_0_199_1291 VPWR VGND VPWR VGND sky130_ef_sc_hd__decap_12
XFILLER_0_214_531 VGND VGND VPWR VPWR sky130_fd_sc_hd__fill_1
XFILLER_0_226_380 VPWR VGND VPWR VGND sky130_ef_sc_hd__decap_12
XFILLER_0_96_1263 VPWR VGND VPWR VGND sky130_ef_sc_hd__decap_12
XFILLER_0_57_1225 VPWR VGND VPWR VGND sky130_ef_sc_hd__decap_12
XFILLER_0_167_641 VGND VGND VPWR VPWR sky130_fd_sc_hd__decap_4
XFILLER_0_57_617 VPWR VGND VPWR VGND sky130_ef_sc_hd__decap_12
XFILLER_0_210_781 VGND VGND VPWR VPWR sky130_fd_sc_hd__decap_3
XPHY_940 VGND VGND VPWR VPWR sky130_fd_sc_hd__decap_3
XFILLER_0_60_29 VPWR VGND VPWR VGND sky130_ef_sc_hd__decap_12
XPHY_962 VGND VGND VPWR VPWR sky130_fd_sc_hd__decap_3
XPHY_951 VGND VGND VPWR VPWR sky130_fd_sc_hd__decap_3
XPHY_984 VGND VGND VPWR VPWR sky130_fd_sc_hd__decap_3
XFILLER_0_182_655 VGND VGND VPWR VPWR sky130_fd_sc_hd__decap_4
XPHY_995 VGND VGND VPWR VPWR sky130_fd_sc_hd__decap_3
XPHY_973 VGND VGND VPWR VPWR sky130_fd_sc_hd__decap_3
XFILLER_0_167_1213 VPWR VGND VPWR VGND sky130_ef_sc_hd__decap_12
XFILLER_0_5_909 VPWR VGND VPWR VGND sky130_ef_sc_hd__decap_12
XFILLER_0_33_1291 VPWR VGND VPWR VGND sky130_ef_sc_hd__decap_12
XFILLER_0_167_1279 VPWR VGND VPWR VGND sky130_ef_sc_hd__decap_12
XFILLER_0_4_419 VGND VGND VPWR VPWR sky130_fd_sc_hd__fill_1
XFILLER_0_80_631 VPWR VGND VPWR VGND sky130_ef_sc_hd__decap_12
XFILLER_0_68_1343 VGND VGND VPWR VPWR sky130_fd_sc_hd__fill_1
XFILLER_0_135_593 VPWR VGND VPWR VGND sky130_ef_sc_hd__decap_12
XFILLER_0_69_27 VPWR VGND VPWR VGND sky130_ef_sc_hd__decap_12
XFILLER_0_107_273 VGND VGND VPWR VPWR sky130_fd_sc_hd__decap_6
XFILLER_0_0_603 VPWR VGND VPWR VGND sky130_ef_sc_hd__decap_12
XFILLER_0_0_625 VPWR VGND VPWR VGND sky130_ef_sc_hd__decap_12
XFILLER_0_0_669 VGND VGND VPWR VPWR sky130_fd_sc_hd__decap_3
XFILLER_0_85_15 VPWR VGND VPWR VGND sky130_ef_sc_hd__decap_12
XFILLER_0_178_1331 VGND VGND VPWR VPWR sky130_fd_sc_hd__decap_6
XFILLER_0_104_1285 VGND VGND VPWR VPWR sky130_fd_sc_hd__decap_3
XFILLER_0_218_881 VPWR VGND VPWR VGND sky130_ef_sc_hd__decap_12
XFILLER_0_40_1251 VPWR VGND VPWR VGND sky130_ef_sc_hd__decap_12
XFILLER_0_109_55 VGND VGND VPWR VPWR sky130_fd_sc_hd__fill_1
XFILLER_0_217_391 VGND VGND VPWR VPWR sky130_fd_sc_hd__fill_1
XFILLER_0_174_1239 VPWR VGND VPWR VGND sky130_ef_sc_hd__decap_12
XFILLER_0_40_1295 VPWR VGND VPWR VGND sky130_ef_sc_hd__decap_12
XFILLER_0_75_1303 VGND VGND VPWR VPWR sky130_fd_sc_hd__decap_6
XFILLER_0_220_501 VPWR VGND VPWR VGND sky130_ef_sc_hd__decap_12
XFILLER_0_192_49 VGND VGND VPWR VPWR sky130_fd_sc_hd__fill_1
XFILLER_0_215_1225 VGND VGND VPWR VPWR sky130_fd_sc_hd__decap_6
XFILLER_0_215_1269 VPWR VGND VPWR VGND sky130_ef_sc_hd__decap_12
XFILLER_0_220_545 VPWR VGND VPWR VGND sky130_ef_sc_hd__decap_12
XFILLER_0_34_41 VGND VGND VPWR VPWR sky130_fd_sc_hd__decap_8
XFILLER_0_48_617 VGND VGND VPWR VPWR sky130_fd_sc_hd__fill_1
XFILLER_0_220_589 VPWR VGND VPWR VGND sky130_ef_sc_hd__decap_12
XFILLER_0_111_1201 VPWR VGND VPWR VGND sky130_ef_sc_hd__decap_12
XFILLER_0_150_1283 VPWR VGND VPWR VGND sky130_ef_sc_hd__decap_12
XFILLER_0_111_1245 VPWR VGND VPWR VGND sky130_ef_sc_hd__decap_12
XFILLER_0_173_655 VGND VGND VPWR VPWR sky130_fd_sc_hd__fill_2
XFILLER_0_1_1329 VGND VGND VPWR VPWR sky130_fd_sc_hd__fill_1
XFILLER_0_12_1331 VGND VGND VPWR VPWR sky130_fd_sc_hd__decap_6
XFILLER_0_146_1319 VPWR VGND VPWR VGND sky130_ef_sc_hd__decap_12
XFILLER_0_111_1289 VPWR VGND VPWR VGND sky130_ef_sc_hd__decap_12
XANTENNA_u_pe01_weight_in[4] net127 VGND VGND VPWR VPWR sky130_fd_sc_hd__diode_2
XFILLER_0_126_593 VPWR VGND VPWR VGND sky130_ef_sc_hd__decap_12
XFILLER_0_82_1307 VPWR VGND VPWR VGND sky130_ef_sc_hd__decap_12
XFILLER_0_3_441 VGND VGND VPWR VPWR sky130_fd_sc_hd__decap_6
XFILLER_0_222_1229 VPWR VGND VPWR VGND sky130_ef_sc_hd__decap_12
XFILLER_0_3_485 VPWR VGND VPWR VGND sky130_ef_sc_hd__decap_12
XFILLER_0_110_961 VPWR VGND VPWR VGND sky130_ef_sc_hd__decap_12
XANTENNA_u_pe00_act_in[9] net16 VGND VGND VPWR VPWR sky130_fd_sc_hd__diode_2
XFILLER_0_215_317 VPWR VGND VPWR VGND sky130_ef_sc_hd__decap_12
XFILLER_0_192_1339 VGND VGND VPWR VPWR sky130_fd_sc_hd__decap_4
XFILLER_0_223_361 VPWR VGND VPWR VGND sky130_ef_sc_hd__decap_12
XFILLER_0_39_617 VPWR VGND VPWR VGND sky130_ef_sc_hd__decap_12
XFILLER_0_6_1229 VPWR VGND VPWR VGND sky130_ef_sc_hd__decap_12
XFILLER_0_149_641 VGND VGND VPWR VPWR sky130_fd_sc_hd__decap_4
XFILLER_0_109_505 VPWR VGND VPWR VGND sky130_ef_sc_hd__decap_12
XPHY_214 VGND VGND VPWR VPWR sky130_fd_sc_hd__decap_3
XPHY_203 VGND VGND VPWR VPWR sky130_fd_sc_hd__decap_3
XFILLER_0_17_1253 VGND VGND VPWR VPWR sky130_fd_sc_hd__fill_1
XPHY_225 VGND VGND VPWR VPWR sky130_fd_sc_hd__decap_3
XPHY_247 VGND VGND VPWR VPWR sky130_fd_sc_hd__decap_3
XPHY_258 VGND VGND VPWR VPWR sky130_fd_sc_hd__decap_3
XPHY_236 VGND VGND VPWR VPWR sky130_fd_sc_hd__decap_3
XFILLER_0_164_655 VGND VGND VPWR VPWR sky130_fd_sc_hd__decap_4
XPHY_269 VGND VGND VPWR VPWR sky130_fd_sc_hd__decap_3
XFILLER_0_62_631 VPWR VGND VPWR VGND sky130_ef_sc_hd__decap_12
XFILLER_0_117_593 VPWR VGND VPWR VGND sky130_ef_sc_hd__decap_12
XFILLER_0_104_221 VGND VGND VPWR VPWR sky130_fd_sc_hd__decap_3
XFILLER_0_105_777 VGND VGND VPWR VPWR sky130_fd_sc_hd__decap_6
XFILLER_0_104_265 VPWR VGND VPWR VGND sky130_ef_sc_hd__decap_12
XFILLER_0_24_1213 VPWR VGND VPWR VGND sky130_ef_sc_hd__decap_12
XANTENNA_input43_A psum_col0_in[18] VGND VGND VPWR VPWR sky130_fd_sc_hd__diode_2
XFILLER_0_218_133 VGND VGND VPWR VPWR sky130_fd_sc_hd__decap_6
XFILLER_0_218_177 VPWR VGND VPWR VGND sky130_ef_sc_hd__decap_12
XFILLER_0_59_1309 VGND VGND VPWR VPWR sky130_fd_sc_hd__fill_1
XFILLER_0_226_20 VGND VGND VPWR VPWR sky130_fd_sc_hd__decap_3
XFILLER_0_215_895 VGND VGND VPWR VPWR sky130_fd_sc_hd__fill_1
XFILLER_0_134_1201 VPWR VGND VPWR VGND sky130_ef_sc_hd__decap_12
XFILLER_0_71_39 VGND VGND VPWR VPWR sky130_fd_sc_hd__decap_8
XFILLER_0_210_1177 VPWR VGND VPWR VGND sky130_ef_sc_hd__decap_12
XPHY_781 VGND VGND VPWR VPWR sky130_fd_sc_hd__decap_3
XFILLER_0_155_655 VGND VGND VPWR VPWR sky130_fd_sc_hd__fill_2
XPHY_770 VGND VGND VPWR VPWR sky130_fd_sc_hd__decap_3
XPHY_792 VGND VGND VPWR VPWR sky130_fd_sc_hd__decap_3
XFILLER_0_187_27 VPWR VGND VPWR VGND sky130_ef_sc_hd__decap_12
XFILLER_0_1_945 VGND VGND VPWR VPWR sky130_fd_sc_hd__decap_6
XFILLER_0_141_1249 VGND VGND VPWR VPWR sky130_fd_sc_hd__decap_4
XFILLER_0_0_455 VGND VGND VPWR VPWR sky130_fd_sc_hd__decap_8
XFILLER_0_0_477 VGND VGND VPWR VPWR sky130_fd_sc_hd__decap_8
XFILLER_0_1_989 VPWR VGND VPWR VGND sky130_ef_sc_hd__decap_12
XFILLER_0_225_615 VGND VGND VPWR VPWR sky130_fd_sc_hd__fill_1
XFILLER_0_104_1093 VPWR VGND VPWR VGND sky130_ef_sc_hd__decap_12
XFILLER_0_212_309 VPWR VGND VPWR VGND sky130_ef_sc_hd__decap_12
XFILLER_0_79_1291 VPWR VGND VPWR VGND sky130_ef_sc_hd__decap_12
XFILLER_0_221_821 VPWR VGND VPWR VGND sky130_ef_sc_hd__decap_12
XFILLER_0_215_1033 VPWR VGND VPWR VGND sky130_ef_sc_hd__decap_12
XFILLER_0_221_865 VPWR VGND VPWR VGND sky130_ef_sc_hd__decap_12
XFILLER_0_215_1077 VPWR VGND VPWR VGND sky130_ef_sc_hd__decap_12
XFILLER_0_0_75 VGND VGND VPWR VPWR sky130_fd_sc_hd__decap_8
XFILLER_0_0_53 VGND VGND VPWR VPWR sky130_fd_sc_hd__decap_3
XFILLER_0_152_41 VGND VGND VPWR VPWR sky130_fd_sc_hd__decap_8
XFILLER_0_146_655 VGND VGND VPWR VPWR sky130_fd_sc_hd__decap_4
XFILLER_0_0_97 VPWR VGND VPWR VGND sky130_ef_sc_hd__decap_12
XFILLER_0_44_631 VPWR VGND VPWR VGND sky130_ef_sc_hd__decap_12
XFILLER_0_161_647 VGND VGND VPWR VPWR sky130_fd_sc_hd__decap_8
XFILLER_0_47_1213 VPWR VGND VPWR VGND sky130_ef_sc_hd__decap_12
XFILLER_0_86_1251 VPWR VGND VPWR VGND sky130_ef_sc_hd__decap_12
XFILLER_0_86_1295 VPWR VGND VPWR VGND sky130_ef_sc_hd__decap_12
XFILLER_0_114_585 VGND VGND VPWR VPWR sky130_fd_sc_hd__decap_3
XFILLER_0_47_1279 VPWR VGND VPWR VGND sky130_ef_sc_hd__decap_12
XFILLER_0_222_1037 VPWR VGND VPWR VGND sky130_ef_sc_hd__decap_12
XFILLER_0_3_293 VPWR VGND VPWR VGND sky130_ef_sc_hd__decap_12
XFILLER_0_216_637 VGND VGND VPWR VPWR sky130_fd_sc_hd__decap_6
XFILLER_0_215_125 VPWR VGND VPWR VGND sky130_ef_sc_hd__decap_12
XFILLER_0_157_1201 VPWR VGND VPWR VGND sky130_ef_sc_hd__decap_12
XFILLER_0_196_1283 VPWR VGND VPWR VGND sky130_ef_sc_hd__decap_12
XFILLER_0_215_169 VPWR VGND VPWR VGND sky130_ef_sc_hd__decap_12
XFILLER_0_157_1267 VPWR VGND VPWR VGND sky130_ef_sc_hd__decap_12
XFILLER_0_58_1331 VGND VGND VPWR VPWR sky130_fd_sc_hd__decap_6
XFILLER_0_224_681 VPWR VGND VPWR VGND sky130_ef_sc_hd__decap_12
XFILLER_0_93_1255 VPWR VGND VPWR VGND sky130_ef_sc_hd__decap_12
XFILLER_0_54_1239 VPWR VGND VPWR VGND sky130_ef_sc_hd__decap_12
XFILLER_0_6_1037 VPWR VGND VPWR VGND sky130_ef_sc_hd__decap_12
XFILLER_0_137_655 VGND VGND VPWR VPWR sky130_fd_sc_hd__fill_2
XFILLER_0_109_335 VGND VGND VPWR VPWR sky130_fd_sc_hd__fill_1
XFILLER_0_129_1303 VGND VGND VPWR VPWR sky130_fd_sc_hd__decap_6
XANTENNA_u_pe01_act_in[0] act_00_out_01_in\[0\] VGND VGND VPWR VPWR sky130_fd_sc_hd__diode_2
XFILLER_0_212_77 VGND VGND VPWR VPWR sky130_fd_sc_hd__decap_6
XFILLER_0_164_1227 VPWR VGND VPWR VGND sky130_ef_sc_hd__decap_12
XFILLER_0_30_1283 VPWR VGND VPWR VGND sky130_ef_sc_hd__decap_12
XFILLER_0_105_541 VPWR VGND VPWR VGND sky130_ef_sc_hd__decap_12
XFILLER_0_65_1335 VGND VGND VPWR VPWR sky130_fd_sc_hd__fill_1
XFILLER_0_205_1213 VPWR VGND VPWR VGND sky130_ef_sc_hd__decap_12
XFILLER_0_105_585 VPWR VGND VPWR VGND sky130_ef_sc_hd__decap_12
XFILLER_0_26_1319 VPWR VGND VPWR VGND sky130_ef_sc_hd__decap_12
XFILLER_0_205_1279 VPWR VGND VPWR VGND sky130_ef_sc_hd__decap_12
XFILLER_0_175_1323 VPWR VGND VPWR VGND sky130_ef_sc_hd__decap_12
XFILLER_0_219_497 VGND VGND VPWR VPWR sky130_fd_sc_hd__decap_6
XFILLER_0_101_1255 VPWR VGND VPWR VGND sky130_ef_sc_hd__decap_12
XFILLER_0_136_1307 VPWR VGND VPWR VGND sky130_ef_sc_hd__decap_12
XFILLER_0_82_27 VGND VGND VPWR VPWR sky130_fd_sc_hd__fill_1
XFILLER_0_82_49 VGND VGND VPWR VPWR sky130_fd_sc_hd__fill_1
XFILLER_0_72_1339 VGND VGND VPWR VPWR sky130_fd_sc_hd__decap_4
XFILLER_0_212_1217 VPWR VGND VPWR VGND sky130_ef_sc_hd__decap_12
XFILLER_0_128_655 VGND VGND VPWR VPWR sky130_fd_sc_hd__decap_4
XFILLER_0_122_22 VGND VGND VPWR VPWR sky130_fd_sc_hd__decap_6
XFILLER_0_215_3 VPWR VGND VPWR VGND sky130_ef_sc_hd__decap_12
XFILLER_0_5_503 VGND VGND VPWR VPWR sky130_fd_sc_hd__fill_1
XFILLER_0_26_631 VPWR VGND VPWR VGND sky130_ef_sc_hd__decap_12
XFILLER_0_198_15 VPWR VGND VPWR VGND sky130_ef_sc_hd__decap_12
XFILLER_0_143_647 VGND VGND VPWR VPWR sky130_fd_sc_hd__decap_8
XFILLER_0_223_1313 VPWR VGND VPWR VGND sky130_ef_sc_hd__decap_12
XFILLER_0_41_645 VGND VGND VPWR VPWR sky130_fd_sc_hd__fill_1
XFILLER_0_1_753 VPWR VGND VPWR VGND sky130_ef_sc_hd__decap_12
XFILLER_0_1_797 VPWR VGND VPWR VGND sky130_ef_sc_hd__decap_12
XFILLER_0_226_946 VGND VGND VPWR VPWR sky130_fd_sc_hd__fill_1
XFILLER_0_213_629 VPWR VGND VPWR VGND sky130_ef_sc_hd__decap_12
XTAP_2409 VGND VPWR sky130_fd_sc_hd__tapvpwrvgnd_1
XFILLER_0_22_3 VPWR VGND VPWR VGND sky130_ef_sc_hd__decap_12
XFILLER_0_212_139 VGND VGND VPWR VPWR sky130_fd_sc_hd__fill_1
XFILLER_0_221_673 VPWR VGND VPWR VGND sky130_ef_sc_hd__decap_12
XFILLER_0_7_1313 VGND VGND VPWR VPWR sky130_fd_sc_hd__decap_3
XTAP_1708 VGND VPWR sky130_fd_sc_hd__tapvpwrvgnd_1
XTAP_1719 VGND VPWR sky130_fd_sc_hd__tapvpwrvgnd_1
XFILLER_0_14_1201 VPWR VGND VPWR VGND sky130_ef_sc_hd__decap_12
XFILLER_0_187_1249 VGND VGND VPWR VPWR sky130_fd_sc_hd__decap_4
XFILLER_0_107_839 VGND VGND VPWR VPWR sky130_fd_sc_hd__fill_1
XFILLER_0_114_393 VPWR VGND VPWR VGND sky130_ef_sc_hd__decap_12
XFILLER_0_216_401 VPWR VGND VPWR VGND sky130_ef_sc_hd__decap_12
XANTENNA_input145_A w10[6] VGND VGND VPWR VPWR sky130_fd_sc_hd__diode_2
XFILLER_0_21_1249 VGND VGND VPWR VPWR sky130_fd_sc_hd__decap_4
XFILLER_0_216_445 VPWR VGND VPWR VGND sky130_ef_sc_hd__decap_12
XFILLER_0_216_489 VPWR VGND VPWR VGND sky130_ef_sc_hd__decap_12
XFILLER_0_99_645 VGND VGND VPWR VPWR sky130_fd_sc_hd__fill_1
XTAP_2910 VGND VPWR sky130_fd_sc_hd__tapvpwrvgnd_1
XTAP_2921 VGND VPWR sky130_fd_sc_hd__tapvpwrvgnd_1
XTAP_2954 VGND VPWR sky130_fd_sc_hd__tapvpwrvgnd_1
XTAP_2943 VGND VPWR sky130_fd_sc_hd__tapvpwrvgnd_1
XTAP_2932 VGND VPWR sky130_fd_sc_hd__tapvpwrvgnd_1
XTAP_2965 VGND VPWR sky130_fd_sc_hd__tapvpwrvgnd_1
XFILLER_0_211_161 VGND VGND VPWR VPWR sky130_fd_sc_hd__decap_6
XFILLER_0_170_1275 VGND VGND VPWR VPWR sky130_fd_sc_hd__decap_6
XFILLER_0_131_1237 VPWR VGND VPWR VGND sky130_ef_sc_hd__decap_12
XFILLER_0_125_647 VPWR VGND VPWR VGND sky130_ef_sc_hd__decap_12
XFILLER_0_113_809 VPWR VGND VPWR VGND sky130_ef_sc_hd__decap_12
XFILLER_0_106_861 VGND VGND VPWR VPWR sky130_fd_sc_hd__decap_6
XFILLER_0_140_617 VGND VGND VPWR VPWR sky130_fd_sc_hd__fill_1
XFILLER_0_23_645 VGND VGND VPWR VPWR sky130_fd_sc_hd__fill_1
XFILLER_0_105_393 VPWR VGND VPWR VGND sky130_ef_sc_hd__decap_12
XFILLER_0_168_29 VPWR VGND VPWR VGND sky130_ef_sc_hd__decap_12
XFILLER_0_219_261 VPWR VGND VPWR VGND sky130_ef_sc_hd__decap_12
XFILLER_0_93_15 VPWR VGND VPWR VGND sky130_ef_sc_hd__decap_12
XFILLER_0_37_1201 VPWR VGND VPWR VGND sky130_ef_sc_hd__decap_12
XFILLER_0_76_1283 VPWR VGND VPWR VGND sky130_ef_sc_hd__decap_12
XFILLER_0_165_3 VPWR VGND VPWR VGND sky130_ef_sc_hd__decap_12
XFILLER_0_216_1161 VPWR VGND VPWR VGND sky130_ef_sc_hd__decap_12
XFILLER_0_37_1267 VPWR VGND VPWR VGND sky130_ef_sc_hd__decap_12
XFILLER_0_133_10 VPWR VGND VPWR VGND sky130_ef_sc_hd__decap_12
XFILLER_0_42_41 VGND VGND VPWR VPWR sky130_fd_sc_hd__decap_8
XFILLER_0_91_6 VGND VGND VPWR VPWR sky130_fd_sc_hd__fill_2
XFILLER_0_104_809 VGND VGND VPWR VPWR sky130_fd_sc_hd__decap_3
XFILLER_0_6_867 VGND VGND VPWR VPWR sky130_fd_sc_hd__fill_1
XFILLER_0_147_1255 VPWR VGND VPWR VGND sky130_ef_sc_hd__decap_12
XFILLER_0_108_1217 VPWR VGND VPWR VGND sky130_ef_sc_hd__decap_12
XFILLER_0_131_617 VPWR VGND VPWR VGND sky130_ef_sc_hd__decap_12
XFILLER_0_223_1121 VPWR VGND VPWR VGND sky130_ef_sc_hd__decap_12
XANTENNA_u_pe01_psum_in[16] net73 VGND VGND VPWR VPWR sky130_fd_sc_hd__diode_2
XFILLER_0_44_1227 VPWR VGND VPWR VGND sky130_ef_sc_hd__decap_12
XFILLER_0_1_561 VPWR VGND VPWR VGND sky130_ef_sc_hd__decap_12
XFILLER_0_6_41 VPWR VGND VPWR VGND sky130_ef_sc_hd__decap_12
XFILLER_0_111_385 VGND VGND VPWR VPWR sky130_fd_sc_hd__decap_6
XFILLER_0_226_732 VGND VGND VPWR VPWR sky130_fd_sc_hd__fill_2
XFILLER_0_226_710 VPWR VGND VPWR VGND sky130_ef_sc_hd__decap_12
XFILLER_0_6_85 VPWR VGND VPWR VGND sky130_ef_sc_hd__decap_12
XFILLER_0_226_776 VGND VGND VPWR VPWR sky130_fd_sc_hd__decap_8
XFILLER_0_226_754 VGND VGND VPWR VPWR sky130_fd_sc_hd__fill_2
XFILLER_0_214_905 VPWR VGND VPWR VGND sky130_ef_sc_hd__decap_12
XFILLER_0_193_1253 VGND VGND VPWR VPWR sky130_fd_sc_hd__fill_1
XFILLER_0_226_798 VPWR VGND VPWR VGND sky130_ef_sc_hd__decap_12
XFILLER_0_214_949 VPWR VGND VPWR VGND sky130_ef_sc_hd__decap_12
XFILLER_0_198_617 VGND VGND VPWR VPWR sky130_fd_sc_hd__fill_1
XFILLER_0_119_1335 VGND VGND VPWR VPWR sky130_fd_sc_hd__fill_1
XTAP_2206 VGND VPWR sky130_fd_sc_hd__tapvpwrvgnd_1
XFILLER_0_55_1323 VPWR VGND VPWR VGND sky130_ef_sc_hd__decap_12
XTAP_2217 VGND VPWR sky130_fd_sc_hd__tapvpwrvgnd_1
XTAP_2239 VGND VPWR sky130_fd_sc_hd__tapvpwrvgnd_1
XTAP_2228 VGND VPWR sky130_fd_sc_hd__tapvpwrvgnd_1
XFILLER_0_90_1225 VGND VGND VPWR VPWR sky130_fd_sc_hd__fill_1
XPHY_12 VGND VGND VPWR VPWR sky130_fd_sc_hd__decap_3
XFILLER_0_16_1307 VPWR VGND VPWR VGND sky130_ef_sc_hd__decap_12
XTAP_1505 VGND VPWR sky130_fd_sc_hd__tapvpwrvgnd_1
XFILLER_0_222_993 VPWR VGND VPWR VGND sky130_ef_sc_hd__decap_12
XPHY_34 VGND VGND VPWR VPWR sky130_fd_sc_hd__decap_3
XPHY_23 VGND VGND VPWR VPWR sky130_fd_sc_hd__decap_3
XTAP_1538 VGND VPWR sky130_fd_sc_hd__tapvpwrvgnd_1
XFILLER_0_7_1121 VPWR VGND VPWR VGND sky130_ef_sc_hd__decap_12
XPHY_45 VGND VGND VPWR VPWR sky130_fd_sc_hd__decap_3
XPHY_56 VGND VGND VPWR VPWR sky130_fd_sc_hd__decap_3
XTAP_1516 VGND VPWR sky130_fd_sc_hd__tapvpwrvgnd_1
XTAP_1527 VGND VPWR sky130_fd_sc_hd__tapvpwrvgnd_1
XTAP_1549 VGND VPWR sky130_fd_sc_hd__tapvpwrvgnd_1
XPHY_89 VGND VGND VPWR VPWR sky130_fd_sc_hd__decap_3
XPHY_67 VGND VGND VPWR VPWR sky130_fd_sc_hd__decap_3
XPHY_78 VGND VGND VPWR VPWR sky130_fd_sc_hd__decap_3
XFILLER_0_3_1007 VGND VGND VPWR VPWR sky130_fd_sc_hd__fill_1
XFILLER_0_130_1281 VGND VGND VPWR VPWR sky130_fd_sc_hd__fill_1
XFILLER_0_165_1311 VPWR VGND VPWR VGND sky130_ef_sc_hd__decap_12
XFILLER_0_122_617 VGND VGND VPWR VPWR sky130_fd_sc_hd__fill_1
XFILLER_0_126_1339 VGND VGND VPWR VPWR sky130_fd_sc_hd__decap_4
XFILLER_0_202_1227 VPWR VGND VPWR VGND sky130_ef_sc_hd__decap_12
XFILLER_0_217_721 VGND VGND VPWR VPWR sky130_fd_sc_hd__decap_6
XFILLER_0_217_765 VPWR VGND VPWR VGND sky130_ef_sc_hd__decap_12
XFILLER_0_218_65 VPWR VGND VPWR VGND sky130_ef_sc_hd__decap_12
XFILLER_0_189_617 VPWR VGND VPWR VGND sky130_ef_sc_hd__decap_12
XFILLER_0_216_253 VPWR VGND VPWR VGND sky130_ef_sc_hd__decap_12
XFILLER_0_172_1337 VGND VGND VPWR VPWR sky130_fd_sc_hd__fill_1
XFILLER_0_213_1301 VPWR VGND VPWR VGND sky130_ef_sc_hd__decap_12
XTAP_2751 VGND VPWR sky130_fd_sc_hd__tapvpwrvgnd_1
XTAP_2773 VGND VPWR sky130_fd_sc_hd__tapvpwrvgnd_1
XTAP_2762 VGND VPWR sky130_fd_sc_hd__tapvpwrvgnd_1
XTAP_2740 VGND VPWR sky130_fd_sc_hd__tapvpwrvgnd_1
XTAP_2795 VGND VPWR sky130_fd_sc_hd__tapvpwrvgnd_1
XFILLER_0_200_643 VPWR VGND VPWR VGND sky130_ef_sc_hd__decap_12
XTAP_2784 VGND VPWR sky130_fd_sc_hd__tapvpwrvgnd_1
XFILLER_0_179_39 VGND VGND VPWR VPWR sky130_fd_sc_hd__decap_8
XFILLER_0_113_617 VPWR VGND VPWR VGND sky130_ef_sc_hd__decap_12
XFILLER_0_67_1249 VGND VGND VPWR VPWR sky130_fd_sc_hd__decap_4
XFILLER_0_88_15 VPWR VGND VPWR VGND sky130_ef_sc_hd__decap_12
XFILLER_0_195_27 VPWR VGND VPWR VGND sky130_ef_sc_hd__decap_12
XFILLER_0_56_9 VGND VGND VPWR VPWR sky130_fd_sc_hd__fill_2
XFILLER_0_177_1237 VPWR VGND VPWR VGND sky130_ef_sc_hd__decap_12
XFILLER_0_222_245 VGND VGND VPWR VPWR sky130_fd_sc_hd__decap_6
XFILLER_0_222_289 VPWR VGND VPWR VGND sky130_ef_sc_hd__decap_12
XFILLER_0_93_629 VPWR VGND VPWR VGND sky130_ef_sc_hd__decap_12
XPHY_1209 VGND VGND VPWR VPWR sky130_fd_sc_hd__decap_3
XFILLER_0_110_1129 VPWR VGND VPWR VGND sky130_ef_sc_hd__decap_12
XFILLER_0_11_1237 VPWR VGND VPWR VGND sky130_ef_sc_hd__decap_12
XFILLER_0_50_1275 VGND VGND VPWR VPWR sky130_fd_sc_hd__decap_6
XFILLER_0_160_41 VGND VGND VPWR VPWR sky130_fd_sc_hd__decap_8
XFILLER_0_2_1073 VPWR VGND VPWR VGND sky130_ef_sc_hd__decap_12
XFILLER_0_104_617 VPWR VGND VPWR VGND sky130_ef_sc_hd__decap_12
XFILLER_0_160_1263 VPWR VGND VPWR VGND sky130_ef_sc_hd__decap_12
XFILLER_0_121_1225 VPWR VGND VPWR VGND sky130_ef_sc_hd__decap_12
XFILLER_0_2_881 VPWR VGND VPWR VGND sky130_ef_sc_hd__decap_12
XFILLER_0_1_391 VGND VGND VPWR VPWR sky130_fd_sc_hd__fill_1
XFILLER_0_111_193 VPWR VGND VPWR VGND sky130_ef_sc_hd__decap_12
XFILLER_0_219_1009 VPWR VGND VPWR VGND sky130_ef_sc_hd__decap_12
XFILLER_0_226_540 VGND VGND VPWR VPWR sky130_fd_sc_hd__decap_8
XFILLER_0_214_713 VPWR VGND VPWR VGND sky130_ef_sc_hd__decap_12
XFILLER_0_214_757 VPWR VGND VPWR VGND sky130_ef_sc_hd__decap_12
XFILLER_0_213_223 VGND VGND VPWR VPWR sky130_fd_sc_hd__fill_1
XTAP_2014 VGND VPWR sky130_fd_sc_hd__tapvpwrvgnd_1
XTAP_2003 VGND VPWR sky130_fd_sc_hd__tapvpwrvgnd_1
XTAP_2025 VGND VPWR sky130_fd_sc_hd__tapvpwrvgnd_1
XTAP_2047 VGND VPWR sky130_fd_sc_hd__tapvpwrvgnd_1
XTAP_2036 VGND VPWR sky130_fd_sc_hd__tapvpwrvgnd_1
XTAP_2058 VGND VPWR sky130_fd_sc_hd__tapvpwrvgnd_1
XTAP_1302 VGND VPWR sky130_fd_sc_hd__tapvpwrvgnd_1
XTAP_1313 VGND VPWR sky130_fd_sc_hd__tapvpwrvgnd_1
XFILLER_0_9_1249 VGND VGND VPWR VPWR sky130_fd_sc_hd__decap_4
XFILLER_0_194_631 VPWR VGND VPWR VGND sky130_ef_sc_hd__decap_12
XFILLER_0_132_1343 VGND VGND VPWR VPWR sky130_fd_sc_hd__fill_1
XTAP_2069 VGND VPWR sky130_fd_sc_hd__tapvpwrvgnd_1
XTAP_1324 VGND VPWR sky130_fd_sc_hd__tapvpwrvgnd_1
XTAP_1335 VGND VPWR sky130_fd_sc_hd__tapvpwrvgnd_1
XTAP_1346 VGND VPWR sky130_fd_sc_hd__tapvpwrvgnd_1
XTAP_1357 VGND VPWR sky130_fd_sc_hd__tapvpwrvgnd_1
XANTENNA_input108_A w00[1] VGND VGND VPWR VPWR sky130_fd_sc_hd__diode_2
XFILLER_0_210_985 VPWR VGND VPWR VGND sky130_ef_sc_hd__decap_12
XTAP_1368 VGND VPWR sky130_fd_sc_hd__tapvpwrvgnd_1
XTAP_1379 VGND VPWR sky130_fd_sc_hd__tapvpwrvgnd_1
XFILLER_0_108_923 VGND VGND VPWR VPWR sky130_fd_sc_hd__fill_1
Xinput19 act_row1_in[11] VGND VGND VPWR VPWR net19 sky130_fd_sc_hd__buf_1
XANTENNA_input73_A psum_col1_in[16] VGND VGND VPWR VPWR sky130_fd_sc_hd__diode_2
XFILLER_0_220_77 VGND VGND VPWR VPWR sky130_fd_sc_hd__decap_6
XFILLER_0_58_29 VPWR VGND VPWR VGND sky130_ef_sc_hd__decap_12
XFILLER_0_27_1255 VPWR VGND VPWR VGND sky130_ef_sc_hd__decap_12
XFILLER_0_199_9 VGND VGND VPWR VPWR sky130_fd_sc_hd__fill_2
XFILLER_0_217_573 VPWR VGND VPWR VGND sky130_ef_sc_hd__decap_12
XFILLER_0_176_1281 VGND VGND VPWR VPWR sky130_fd_sc_hd__fill_1
XFILLER_0_220_749 VGND VGND VPWR VPWR sky130_fd_sc_hd__decap_6
XFILLER_0_73_1253 VGND VGND VPWR VPWR sky130_fd_sc_hd__fill_1
XFILLER_0_90_27 VGND VGND VPWR VPWR sky130_fd_sc_hd__fill_1
XTAP_2581 VGND VPWR sky130_fd_sc_hd__tapvpwrvgnd_1
XTAP_2570 VGND VPWR sky130_fd_sc_hd__tapvpwrvgnd_1
XFILLER_0_75_629 VPWR VGND VPWR VGND sky130_ef_sc_hd__decap_12
XFILLER_0_90_49 VGND VGND VPWR VPWR sky130_fd_sc_hd__fill_1
XFILLER_0_213_1175 VGND VGND VPWR VPWR sky130_fd_sc_hd__fill_1
XTAP_2592 VGND VPWR sky130_fd_sc_hd__tapvpwrvgnd_1
XTAP_1880 VGND VPWR sky130_fd_sc_hd__tapvpwrvgnd_1
XFILLER_0_7_417 VGND VGND VPWR VPWR sky130_fd_sc_hd__decap_3
XTAP_1891 VGND VPWR sky130_fd_sc_hd__tapvpwrvgnd_1
XFILLER_0_128_3 VPWR VGND VPWR VGND sky130_ef_sc_hd__decap_12
XFILLER_0_99_47 VGND VGND VPWR VPWR sky130_fd_sc_hd__decap_3
XFILLER_0_109_1301 VPWR VGND VPWR VGND sky130_ef_sc_hd__decap_12
XFILLER_0_114_937 VPWR VGND VPWR VGND sky130_ef_sc_hd__decap_12
XFILLER_0_144_1225 VGND VGND VPWR VPWR sky130_fd_sc_hd__fill_1
XFILLER_0_10_1281 VGND VGND VPWR VPWR sky130_fd_sc_hd__fill_1
XFILLER_0_45_1311 VPWR VGND VPWR VGND sky130_ef_sc_hd__decap_12
XFILLER_0_113_447 VGND VGND VPWR VPWR sky130_fd_sc_hd__fill_1
XFILLER_0_2_133 VGND VGND VPWR VPWR sky130_fd_sc_hd__decap_6
XFILLER_0_80_1213 VPWR VGND VPWR VGND sky130_ef_sc_hd__decap_12
XFILLER_0_2_177 VPWR VGND VPWR VGND sky130_ef_sc_hd__decap_12
XFILLER_0_190_1201 VPWR VGND VPWR VGND sky130_ef_sc_hd__decap_12
XFILLER_0_211_727 VGND VGND VPWR VPWR sky130_fd_sc_hd__fill_1
XFILLER_0_176_631 VPWR VGND VPWR VGND sky130_ef_sc_hd__decap_12
XFILLER_0_210_237 VPWR VGND VPWR VGND sky130_ef_sc_hd__decap_12
XPHY_407 VGND VGND VPWR VPWR sky130_fd_sc_hd__decap_3
XFILLER_0_52_1337 VGND VGND VPWR VPWR sky130_fd_sc_hd__fill_1
XFILLER_0_109_709 VPWR VGND VPWR VGND sky130_ef_sc_hd__decap_12
XPHY_418 VGND VGND VPWR VPWR sky130_fd_sc_hd__decap_3
XPHY_429 VGND VGND VPWR VPWR sky130_fd_sc_hd__decap_3
XPHY_1006 VGND VGND VPWR VPWR sky130_fd_sc_hd__decap_3
XPHY_1028 VGND VGND VPWR VPWR sky130_fd_sc_hd__decap_3
XPHY_1017 VGND VGND VPWR VPWR sky130_fd_sc_hd__decap_3
XPHY_1039 VGND VGND VPWR VPWR sky130_fd_sc_hd__decap_3
XFILLER_0_191_645 VGND VGND VPWR VPWR sky130_fd_sc_hd__fill_1
XFILLER_0_225_1057 VGND VGND VPWR VPWR sky130_fd_sc_hd__decap_6
XFILLER_0_123_1309 VGND VGND VPWR VPWR sky130_fd_sc_hd__fill_1
XFILLER_0_203_1311 VPWR VGND VPWR VGND sky130_ef_sc_hd__decap_12
XFILLER_0_100_631 VPWR VGND VPWR VGND sky130_ef_sc_hd__decap_12
XFILLER_0_96_1275 VGND VGND VPWR VPWR sky130_fd_sc_hd__decap_6
XFILLER_0_57_1237 VPWR VGND VPWR VGND sky130_ef_sc_hd__decap_12
XFILLER_0_214_587 VGND VGND VPWR VPWR sky130_fd_sc_hd__fill_1
XFILLER_0_215_55 VGND VGND VPWR VPWR sky130_fd_sc_hd__fill_1
XPHY_930 VGND VGND VPWR VPWR sky130_fd_sc_hd__decap_3
XFILLER_0_57_629 VPWR VGND VPWR VGND sky130_ef_sc_hd__decap_12
XPHY_941 VGND VGND VPWR VPWR sky130_fd_sc_hd__decap_3
XPHY_952 VGND VGND VPWR VPWR sky130_fd_sc_hd__decap_3
XPHY_963 VGND VGND VPWR VPWR sky130_fd_sc_hd__decap_3
XPHY_996 VGND VGND VPWR VPWR sky130_fd_sc_hd__decap_3
XPHY_985 VGND VGND VPWR VPWR sky130_fd_sc_hd__decap_3
XPHY_974 VGND VGND VPWR VPWR sky130_fd_sc_hd__decap_3
XFILLER_0_167_1225 VPWR VGND VPWR VGND sky130_ef_sc_hd__decap_12
XFILLER_0_80_643 VPWR VGND VPWR VGND sky130_ef_sc_hd__decap_12
XFILLER_0_69_39 VGND VGND VPWR VPWR sky130_fd_sc_hd__decap_8
XFILLER_0_104_981 VPWR VGND VPWR VGND sky130_ef_sc_hd__decap_12
XFILLER_0_0_637 VGND VGND VPWR VPWR sky130_fd_sc_hd__decap_6
XFILLER_0_0_615 VGND VGND VPWR VPWR sky130_fd_sc_hd__fill_1
XFILLER_0_176_29 VPWR VGND VPWR VGND sky130_ef_sc_hd__decap_12
XFILLER_0_143_1291 VPWR VGND VPWR VGND sky130_ef_sc_hd__decap_12
XFILLER_0_85_27 VPWR VGND VPWR VGND sky130_ef_sc_hd__decap_12
XFILLER_0_224_307 VGND VGND VPWR VPWR sky130_fd_sc_hd__fill_1
XFILLER_0_40_1263 VPWR VGND VPWR VGND sky130_ef_sc_hd__decap_12
XFILLER_0_218_893 VPWR VGND VPWR VGND sky130_ef_sc_hd__decap_12
XFILLER_0_220_513 VPWR VGND VPWR VGND sky130_ef_sc_hd__decap_12
XFILLER_0_220_557 VPWR VGND VPWR VGND sky130_ef_sc_hd__decap_12
XFILLER_0_158_631 VPWR VGND VPWR VGND sky130_ef_sc_hd__decap_12
XFILLER_0_150_1251 VPWR VGND VPWR VGND sky130_ef_sc_hd__decap_12
XFILLER_0_150_1295 VPWR VGND VPWR VGND sky130_ef_sc_hd__decap_12
XFILLER_0_111_1213 VPWR VGND VPWR VGND sky130_ef_sc_hd__decap_12
XFILLER_0_185_1303 VGND VGND VPWR VPWR sky130_fd_sc_hd__decap_6
XFILLER_0_111_1257 VPWR VGND VPWR VGND sky130_ef_sc_hd__decap_12
XFILLER_0_173_645 VGND VGND VPWR VPWR sky130_fd_sc_hd__fill_1
XFILLER_0_50_41 VGND VGND VPWR VPWR sky130_fd_sc_hd__decap_8
XFILLER_0_7_225 VPWR VGND VPWR VGND sky130_ef_sc_hd__decap_12
XFILLER_0_12_1343 VGND VGND VPWR VPWR sky130_fd_sc_hd__fill_1
XANTENNA_u_pe01_weight_in[3] net126 VGND VGND VPWR VPWR sky130_fd_sc_hd__diode_2
XFILLER_0_114_701 VPWR VGND VPWR VGND sky130_ef_sc_hd__decap_12
XFILLER_0_82_1319 VPWR VGND VPWR VGND sky130_ef_sc_hd__decap_12
XFILLER_0_109_1175 VGND VGND VPWR VPWR sky130_fd_sc_hd__fill_1
XFILLER_0_3_497 VGND VGND VPWR VPWR sky130_fd_sc_hd__decap_6
XFILLER_0_122_1331 VGND VGND VPWR VPWR sky130_fd_sc_hd__decap_6
XANTENNA_u_pe00_act_in[8] net15 VGND VGND VPWR VPWR sky130_fd_sc_hd__diode_2
XFILLER_0_110_973 VGND VGND VPWR VPWR sky130_fd_sc_hd__decap_6
XFILLER_0_192_1307 VPWR VGND VPWR VGND sky130_ef_sc_hd__decap_12
XFILLER_0_215_329 VGND VGND VPWR VPWR sky130_fd_sc_hd__decap_6
XFILLER_0_223_373 VPWR VGND VPWR VGND sky130_ef_sc_hd__decap_12
XFILLER_0_56_1281 VGND VGND VPWR VPWR sky130_fd_sc_hd__fill_1
XPHY_215 VGND VGND VPWR VPWR sky130_fd_sc_hd__decap_3
XPHY_204 VGND VGND VPWR VPWR sky130_fd_sc_hd__decap_3
XFILLER_0_39_629 VPWR VGND VPWR VGND sky130_ef_sc_hd__decap_12
XFILLER_0_109_517 VPWR VGND VPWR VGND sky130_ef_sc_hd__decap_12
XPHY_226 VGND VGND VPWR VPWR sky130_fd_sc_hd__decap_3
XPHY_259 VGND VGND VPWR VPWR sky130_fd_sc_hd__decap_3
XPHY_237 VGND VGND VPWR VPWR sky130_fd_sc_hd__decap_3
XPHY_248 VGND VGND VPWR VPWR sky130_fd_sc_hd__decap_3
XFILLER_0_62_643 VPWR VGND VPWR VGND sky130_ef_sc_hd__decap_12
XFILLER_0_7_781 VGND VGND VPWR VPWR sky130_fd_sc_hd__decap_3
XFILLER_0_127_1253 VGND VGND VPWR VPWR sky130_fd_sc_hd__fill_1
XFILLER_0_104_277 VGND VGND VPWR VPWR sky130_fd_sc_hd__decap_3
XFILLER_0_24_1225 VGND VGND VPWR VPWR sky130_fd_sc_hd__fill_1
Xu_pe10 VGND VPWR net17 net18 net19 net20 net21 net22 net23 net24 net25 net26 net27
+ net28 net29 net30 net31 net32 act_10_out_11_in\[0\] act_10_out_11_in\[10\] act_10_out_11_in\[11\]
+ act_10_out_11_in\[12\] act_10_out_11_in\[13\] act_10_out_11_in\[14\] act_10_out_11_in\[15\]
+ act_10_out_11_in\[1\] act_10_out_11_in\[2\] act_10_out_11_in\[3\] act_10_out_11_in\[4\]
+ act_10_out_11_in\[5\] act_10_out_11_in\[6\] act_10_out_11_in\[7\] act_10_out_11_in\[8\]
+ act_10_out_11_in\[9\] clknet_1_0__leaf_clk net33 psum_00_out_10_in\[0\] psum_00_out_10_in\[10\]
+ psum_00_out_10_in\[11\] psum_00_out_10_in\[12\] psum_00_out_10_in\[13\] psum_00_out_10_in\[14\]
+ psum_00_out_10_in\[15\] psum_00_out_10_in\[16\] psum_00_out_10_in\[17\] psum_00_out_10_in\[18\]
+ psum_00_out_10_in\[19\] psum_00_out_10_in\[1\] psum_00_out_10_in\[20\] psum_00_out_10_in\[21\]
+ psum_00_out_10_in\[22\] psum_00_out_10_in\[23\] psum_00_out_10_in\[24\] psum_00_out_10_in\[25\]
+ psum_00_out_10_in\[26\] psum_00_out_10_in\[27\] psum_00_out_10_in\[28\] psum_00_out_10_in\[29\]
+ psum_00_out_10_in\[2\] psum_00_out_10_in\[30\] psum_00_out_10_in\[31\] psum_00_out_10_in\[3\]
+ psum_00_out_10_in\[4\] psum_00_out_10_in\[5\] psum_00_out_10_in\[6\] psum_00_out_10_in\[7\]
+ psum_00_out_10_in\[8\] psum_00_out_10_in\[9\] net165 net166 net167 net168 net169
+ net170 net171 net172 net173 net174 net175 net176 net177 net178 net179 net180 net181
+ net182 net183 net184 net185 net186 net187 net188 net189 net190 net191 net192 net193
+ net194 net195 net196 net98 net100 valid_10_out_11_in net133 net134 net135 net136
+ net137 net138 net139 net140 net141 net142 net143 net144 net145 net146 net147 net148
+ processing_element
XFILLER_0_98_1337 VGND VGND VPWR VPWR sky130_fd_sc_hd__fill_1
XFILLER_0_215_841 VPWR VGND VPWR VGND sky130_ef_sc_hd__decap_12
XANTENNA_input36_A psum_col0_in[11] VGND VGND VPWR VPWR sky130_fd_sc_hd__diode_2
XFILLER_0_218_189 VGND VGND VPWR VPWR sky130_fd_sc_hd__decap_6
XFILLER_0_226_65 VGND VGND VPWR VPWR sky130_fd_sc_hd__fill_2
XFILLER_0_134_1213 VPWR VGND VPWR VGND sky130_ef_sc_hd__decap_12
XFILLER_0_70_1201 VPWR VGND VPWR VGND sky130_ef_sc_hd__decap_12
XFILLER_0_210_1101 VGND VGND VPWR VPWR sky130_fd_sc_hd__fill_2
XFILLER_0_169_1309 VGND VGND VPWR VPWR sky130_fd_sc_hd__fill_1
XFILLER_0_155_645 VGND VGND VPWR VPWR sky130_fd_sc_hd__fill_1
XPHY_760 VGND VGND VPWR VPWR sky130_fd_sc_hd__decap_3
XPHY_771 VGND VGND VPWR VPWR sky130_fd_sc_hd__decap_3
XFILLER_0_210_1189 VPWR VGND VPWR VGND sky130_ef_sc_hd__decap_12
XPHY_793 VGND VGND VPWR VPWR sky130_fd_sc_hd__decap_3
XFILLER_0_5_729 VPWR VGND VPWR VGND sky130_ef_sc_hd__decap_12
XPHY_782 VGND VGND VPWR VPWR sky130_fd_sc_hd__decap_3
XFILLER_0_112_6 VGND VGND VPWR VPWR sky130_fd_sc_hd__fill_2
XFILLER_0_111_57 VPWR VGND VPWR VGND sky130_ef_sc_hd__decap_12
XFILLER_0_187_39 VGND VGND VPWR VPWR sky130_fd_sc_hd__decap_8
XFILLER_0_106_1315 VGND VGND VPWR VPWR sky130_fd_sc_hd__fill_1
XFILLER_0_96_15 VPWR VGND VPWR VGND sky130_ef_sc_hd__decap_12
XFILLER_0_195_3 VPWR VGND VPWR VGND sky130_ef_sc_hd__decap_12
XFILLER_0_104_1061 VGND VGND VPWR VPWR sky130_fd_sc_hd__decap_3
XFILLER_0_136_10 VPWR VGND VPWR VGND sky130_ef_sc_hd__decap_12
XFILLER_0_215_1001 VGND VGND VPWR VPWR sky130_fd_sc_hd__decap_6
XFILLER_0_221_833 VGND VGND VPWR VPWR sky130_fd_sc_hd__decap_6
XFILLER_0_215_1045 VPWR VGND VPWR VGND sky130_ef_sc_hd__decap_12
XFILLER_0_220_321 VPWR VGND VPWR VGND sky130_ef_sc_hd__decap_12
XFILLER_0_215_1089 VPWR VGND VPWR VGND sky130_ef_sc_hd__decap_12
XFILLER_0_221_877 VPWR VGND VPWR VGND sky130_ef_sc_hd__decap_12
XFILLER_0_220_365 VPWR VGND VPWR VGND sky130_ef_sc_hd__decap_12
XFILLER_0_111_1021 VPWR VGND VPWR VGND sky130_ef_sc_hd__decap_12
XFILLER_0_189_1291 VPWR VGND VPWR VGND sky130_ef_sc_hd__decap_12
XFILLER_0_111_1065 VPWR VGND VPWR VGND sky130_ef_sc_hd__decap_12
XFILLER_0_44_643 VPWR VGND VPWR VGND sky130_ef_sc_hd__decap_12
XFILLER_0_47_1225 VPWR VGND VPWR VGND sky130_ef_sc_hd__decap_12
XFILLER_0_86_1263 VPWR VGND VPWR VGND sky130_ef_sc_hd__decap_12
XFILLER_0_222_1005 VPWR VGND VPWR VGND sky130_ef_sc_hd__decap_12
XFILLER_0_3_261 VPWR VGND VPWR VGND sky130_ef_sc_hd__decap_12
XFILLER_0_222_1049 VPWR VGND VPWR VGND sky130_ef_sc_hd__decap_12
XFILLER_0_110_781 VPWR VGND VPWR VGND sky130_ef_sc_hd__decap_12
XFILLER_0_196_1251 VPWR VGND VPWR VGND sky130_ef_sc_hd__decap_12
XFILLER_0_157_1213 VPWR VGND VPWR VGND sky130_ef_sc_hd__decap_12
XFILLER_0_23_1291 VPWR VGND VPWR VGND sky130_ef_sc_hd__decap_12
XFILLER_0_196_1295 VPWR VGND VPWR VGND sky130_ef_sc_hd__decap_12
XFILLER_0_215_137 VPWR VGND VPWR VGND sky130_ef_sc_hd__decap_12
XFILLER_0_93_1201 VPWR VGND VPWR VGND sky130_ef_sc_hd__decap_12
XFILLER_0_212_811 VGND VGND VPWR VPWR sky130_fd_sc_hd__fill_1
XFILLER_0_157_1279 VPWR VGND VPWR VGND sky130_ef_sc_hd__decap_12
XFILLER_0_58_1343 VGND VGND VPWR VPWR sky130_fd_sc_hd__fill_1
XFILLER_0_224_693 VGND VGND VPWR VPWR sky130_fd_sc_hd__decap_6
XFILLER_0_223_181 VPWR VGND VPWR VGND sky130_ef_sc_hd__decap_12
XFILLER_0_93_1267 VPWR VGND VPWR VGND sky130_ef_sc_hd__decap_12
XFILLER_0_6_1005 VPWR VGND VPWR VGND sky130_ef_sc_hd__decap_12
XFILLER_0_6_1049 VPWR VGND VPWR VGND sky130_ef_sc_hd__decap_12
XFILLER_0_137_645 VGND VGND VPWR VPWR sky130_fd_sc_hd__fill_1
XFILLER_0_168_1331 VGND VGND VPWR VPWR sky130_fd_sc_hd__decap_6
XFILLER_0_30_1251 VPWR VGND VPWR VGND sky130_ef_sc_hd__decap_12
XFILLER_0_30_1295 VPWR VGND VPWR VGND sky130_ef_sc_hd__decap_12
XFILLER_0_65_1303 VGND VGND VPWR VPWR sky130_fd_sc_hd__decap_6
XFILLER_0_164_1239 VPWR VGND VPWR VGND sky130_ef_sc_hd__decap_12
XFILLER_0_105_553 VGND VGND VPWR VPWR sky130_fd_sc_hd__decap_6
XFILLER_0_205_1225 VPWR VGND VPWR VGND sky130_ef_sc_hd__decap_12
XFILLER_0_105_597 VPWR VGND VPWR VGND sky130_ef_sc_hd__decap_12
XFILLER_0_207_605 VPWR VGND VPWR VGND sky130_ef_sc_hd__decap_12
XFILLER_0_101_1201 VPWR VGND VPWR VGND sky130_ef_sc_hd__decap_12
XFILLER_0_66_29 VPWR VGND VPWR VGND sky130_ef_sc_hd__decap_12
XFILLER_0_140_1283 VPWR VGND VPWR VGND sky130_ef_sc_hd__decap_12
XFILLER_0_175_1335 VGND VGND VPWR VPWR sky130_fd_sc_hd__decap_8
XFILLER_0_101_1267 VPWR VGND VPWR VGND sky130_ef_sc_hd__decap_12
XFILLER_0_215_671 VGND VGND VPWR VPWR sky130_fd_sc_hd__fill_1
XFILLER_0_136_1319 VPWR VGND VPWR VGND sky130_ef_sc_hd__decap_12
XFILLER_0_72_1307 VPWR VGND VPWR VGND sky130_ef_sc_hd__decap_12
XFILLER_0_212_1229 VPWR VGND VPWR VGND sky130_ef_sc_hd__decap_12
XFILLER_0_112_1341 VGND VGND VPWR VPWR sky130_fd_sc_hd__decap_3
XPHY_590 VGND VGND VPWR VPWR sky130_fd_sc_hd__decap_3
XFILLER_0_26_643 VPWR VGND VPWR VGND sky130_ef_sc_hd__decap_12
XFILLER_0_110_3 VPWR VGND VPWR VGND sky130_ef_sc_hd__decap_12
XFILLER_0_182_1339 VGND VGND VPWR VPWR sky130_fd_sc_hd__decap_4
XFILLER_0_208_3 VPWR VGND VPWR VGND sky130_ef_sc_hd__decap_12
XFILLER_0_198_49 VGND VGND VPWR VPWR sky130_fd_sc_hd__fill_1
XFILLER_0_198_27 VGND VGND VPWR VPWR sky130_fd_sc_hd__fill_1
XFILLER_0_5_559 VGND VGND VPWR VPWR sky130_fd_sc_hd__fill_1
XFILLER_0_223_1325 VPWR VGND VPWR VGND sky130_ef_sc_hd__decap_12
XFILLER_0_1_721 VGND VGND VPWR VPWR sky130_fd_sc_hd__decap_6
XFILLER_0_1_765 VPWR VGND VPWR VGND sky130_ef_sc_hd__decap_12
XFILLER_0_0_253 VPWR VGND VPWR VGND sky130_ef_sc_hd__decap_12
XFILLER_0_0_231 VPWR VGND VPWR VGND sky130_ef_sc_hd__decap_12
XFILLER_0_226_925 VGND VGND VPWR VPWR sky130_fd_sc_hd__fill_2
XFILLER_0_221_641 VPWR VGND VPWR VGND sky130_ef_sc_hd__decap_12
XFILLER_0_15_3 VPWR VGND VPWR VGND sky130_ef_sc_hd__decap_12
XTAP_1709 VGND VPWR sky130_fd_sc_hd__tapvpwrvgnd_1
XFILLER_0_221_685 VPWR VGND VPWR VGND sky130_ef_sc_hd__decap_12
XFILLER_0_14_1213 VPWR VGND VPWR VGND sky130_ef_sc_hd__decap_12
XFILLER_0_220_195 VGND VGND VPWR VPWR sky130_fd_sc_hd__fill_1
XFILLER_0_119_645 VGND VGND VPWR VPWR sky130_fd_sc_hd__fill_1
XFILLER_0_49_1309 VGND VGND VPWR VPWR sky130_fd_sc_hd__fill_1
XFILLER_0_124_1201 VPWR VGND VPWR VGND sky130_ef_sc_hd__decap_12
XFILLER_0_114_361 VGND VGND VPWR VPWR sky130_fd_sc_hd__decap_3
XFILLER_0_4_581 VGND VGND VPWR VPWR sky130_fd_sc_hd__decap_6
XFILLER_0_216_413 VGND VGND VPWR VPWR sky130_fd_sc_hd__decap_6
XFILLER_0_216_457 VPWR VGND VPWR VGND sky130_ef_sc_hd__decap_12
XFILLER_0_204_619 VPWR VGND VPWR VGND sky130_ef_sc_hd__decap_12
XANTENNA_input138_A w10[14] VGND VGND VPWR VPWR sky130_fd_sc_hd__diode_2
XTAP_2911 VGND VPWR sky130_fd_sc_hd__tapvpwrvgnd_1
XTAP_2922 VGND VPWR sky130_fd_sc_hd__tapvpwrvgnd_1
XTAP_2900 VGND VPWR sky130_fd_sc_hd__tapvpwrvgnd_1
XTAP_2955 VGND VPWR sky130_fd_sc_hd__tapvpwrvgnd_1
XTAP_2944 VGND VPWR sky130_fd_sc_hd__tapvpwrvgnd_1
XTAP_2933 VGND VPWR sky130_fd_sc_hd__tapvpwrvgnd_1
XTAP_2966 VGND VPWR sky130_fd_sc_hd__tapvpwrvgnd_1
XFILLER_0_223_55 VGND VGND VPWR VPWR sky130_fd_sc_hd__fill_1
XFILLER_0_131_1249 VGND VGND VPWR VPWR sky130_fd_sc_hd__decap_4
XFILLER_0_109_111 VGND VGND VPWR VPWR sky130_fd_sc_hd__fill_1
XFILLER_0_207_1309 VGND VGND VPWR VPWR sky130_fd_sc_hd__fill_1
XFILLER_0_69_1291 VPWR VGND VPWR VGND sky130_ef_sc_hd__decap_12
XFILLER_0_105_361 VPWR VGND VPWR VGND sky130_ef_sc_hd__decap_12
XFILLER_0_112_309 VPWR VGND VPWR VGND sky130_ef_sc_hd__decap_12
XFILLER_0_219_273 VGND VGND VPWR VPWR sky130_fd_sc_hd__decap_6
XFILLER_0_184_29 VPWR VGND VPWR VGND sky130_ef_sc_hd__decap_12
XFILLER_0_93_27 VPWR VGND VPWR VGND sky130_ef_sc_hd__decap_12
XFILLER_0_203_641 VGND VGND VPWR VPWR sky130_fd_sc_hd__decap_4
XFILLER_0_37_1213 VPWR VGND VPWR VGND sky130_ef_sc_hd__decap_12
XFILLER_0_76_1251 VPWR VGND VPWR VGND sky130_ef_sc_hd__decap_12
XFILLER_0_216_1173 VPWR VGND VPWR VGND sky130_ef_sc_hd__decap_12
XFILLER_0_76_1295 VPWR VGND VPWR VGND sky130_ef_sc_hd__decap_12
XFILLER_0_158_3 VPWR VGND VPWR VGND sky130_ef_sc_hd__decap_12
XFILLER_0_212_1037 VPWR VGND VPWR VGND sky130_ef_sc_hd__decap_12
XFILLER_0_37_1279 VPWR VGND VPWR VGND sky130_ef_sc_hd__decap_12
XFILLER_0_133_22 VPWR VGND VPWR VGND sky130_ef_sc_hd__decap_12
XFILLER_0_147_1201 VPWR VGND VPWR VGND sky130_ef_sc_hd__decap_12
XFILLER_0_6_813 VPWR VGND VPWR VGND sky130_ef_sc_hd__decap_12
XFILLER_0_186_1283 VPWR VGND VPWR VGND sky130_ef_sc_hd__decap_12
XFILLER_0_147_1267 VPWR VGND VPWR VGND sky130_ef_sc_hd__decap_12
XFILLER_0_108_1229 VPWR VGND VPWR VGND sky130_ef_sc_hd__decap_12
XFILLER_0_131_629 VPWR VGND VPWR VGND sky130_ef_sc_hd__decap_12
XFILLER_0_84_6 VGND VGND VPWR VPWR sky130_fd_sc_hd__fill_2
XFILLER_0_48_1331 VGND VGND VPWR VPWR sky130_fd_sc_hd__decap_6
XFILLER_0_223_1133 VPWR VGND VPWR VGND sky130_ef_sc_hd__decap_12
XANTENNA_u_pe01_psum_in[15] net72 VGND VGND VPWR VPWR sky130_fd_sc_hd__diode_2
XFILLER_0_83_1255 VPWR VGND VPWR VGND sky130_ef_sc_hd__decap_12
XFILLER_0_44_1239 VPWR VGND VPWR VGND sky130_ef_sc_hd__decap_12
XFILLER_0_223_1177 VPWR VGND VPWR VGND sky130_ef_sc_hd__decap_12
XFILLER_0_1_573 VPWR VGND VPWR VGND sky130_ef_sc_hd__decap_12
XFILLER_0_6_53 VPWR VGND VPWR VGND sky130_ef_sc_hd__decap_12
XFILLER_0_158_41 VGND VGND VPWR VPWR sky130_fd_sc_hd__decap_8
XFILLER_0_226_722 VGND VGND VPWR VPWR sky130_fd_sc_hd__decap_6
XFILLER_0_6_97 VPWR VGND VPWR VGND sky130_ef_sc_hd__decap_12
XFILLER_0_214_917 VGND VGND VPWR VPWR sky130_fd_sc_hd__decap_6
XFILLER_0_213_405 VPWR VGND VPWR VGND sky130_ef_sc_hd__decap_12
XFILLER_0_119_1303 VGND VGND VPWR VPWR sky130_fd_sc_hd__decap_6
XFILLER_0_20_1283 VPWR VGND VPWR VGND sky130_ef_sc_hd__decap_12
XFILLER_0_213_449 VPWR VGND VPWR VGND sky130_ef_sc_hd__decap_12
XFILLER_0_154_1227 VPWR VGND VPWR VGND sky130_ef_sc_hd__decap_12
XTAP_2207 VGND VPWR sky130_fd_sc_hd__tapvpwrvgnd_1
XFILLER_0_96_605 VPWR VGND VPWR VGND sky130_ef_sc_hd__decap_12
XFILLER_0_222_961 VPWR VGND VPWR VGND sky130_ef_sc_hd__decap_12
XTAP_2229 VGND VPWR sky130_fd_sc_hd__tapvpwrvgnd_1
XTAP_2218 VGND VPWR sky130_fd_sc_hd__tapvpwrvgnd_1
XTAP_1506 VGND VPWR sky130_fd_sc_hd__tapvpwrvgnd_1
XPHY_13 VGND VGND VPWR VPWR sky130_fd_sc_hd__decap_3
XFILLER_0_55_1335 VGND VGND VPWR VPWR sky130_fd_sc_hd__decap_8
XTAP_1517 VGND VPWR sky130_fd_sc_hd__tapvpwrvgnd_1
XPHY_46 VGND VGND VPWR VPWR sky130_fd_sc_hd__decap_3
XPHY_35 VGND VGND VPWR VPWR sky130_fd_sc_hd__decap_3
XPHY_24 VGND VGND VPWR VPWR sky130_fd_sc_hd__decap_3
XFILLER_0_7_1133 VPWR VGND VPWR VGND sky130_ef_sc_hd__decap_12
XFILLER_0_16_1319 VPWR VGND VPWR VGND sky130_ef_sc_hd__decap_12
XTAP_1528 VGND VPWR sky130_fd_sc_hd__tapvpwrvgnd_1
XTAP_1539 VGND VPWR sky130_fd_sc_hd__tapvpwrvgnd_1
XPHY_79 VGND VGND VPWR VPWR sky130_fd_sc_hd__decap_3
XFILLER_0_7_1177 VPWR VGND VPWR VGND sky130_ef_sc_hd__decap_12
XPHY_57 VGND VGND VPWR VPWR sky130_fd_sc_hd__decap_3
XPHY_68 VGND VGND VPWR VPWR sky130_fd_sc_hd__decap_3
XFILLER_0_107_615 VGND VGND VPWR VPWR sky130_fd_sc_hd__fill_1
XFILLER_0_165_1323 VPWR VGND VPWR VGND sky130_ef_sc_hd__decap_12
XFILLER_0_126_1307 VPWR VGND VPWR VGND sky130_ef_sc_hd__decap_12
XFILLER_0_206_1331 VGND VGND VPWR VPWR sky130_fd_sc_hd__decap_6
XFILLER_0_20_605 VPWR VGND VPWR VGND sky130_ef_sc_hd__decap_12
XFILLER_0_62_1339 VGND VGND VPWR VPWR sky130_fd_sc_hd__decap_4
XFILLER_0_202_1239 VPWR VGND VPWR VGND sky130_ef_sc_hd__decap_12
XFILLER_0_4_3 VPWR VGND VPWR VGND sky130_ef_sc_hd__decap_12
XFILLER_0_216_221 VPWR VGND VPWR VGND sky130_ef_sc_hd__decap_12
XFILLER_0_217_777 VGND VGND VPWR VPWR sky130_fd_sc_hd__decap_6
XFILLER_0_218_77 VGND VGND VPWR VPWR sky130_fd_sc_hd__decap_6
XFILLER_0_216_265 VPWR VGND VPWR VGND sky130_ef_sc_hd__decap_12
XFILLER_0_189_629 VPWR VGND VPWR VGND sky130_ef_sc_hd__decap_12
XTAP_2730 VGND VPWR sky130_fd_sc_hd__tapvpwrvgnd_1
XFILLER_0_87_605 VPWR VGND VPWR VGND sky130_ef_sc_hd__decap_12
XTAP_2752 VGND VPWR sky130_fd_sc_hd__tapvpwrvgnd_1
XFILLER_0_213_1313 VPWR VGND VPWR VGND sky130_ef_sc_hd__decap_12
XTAP_2741 VGND VPWR sky130_fd_sc_hd__tapvpwrvgnd_1
XTAP_2763 VGND VPWR sky130_fd_sc_hd__tapvpwrvgnd_1
XTAP_2774 VGND VPWR sky130_fd_sc_hd__tapvpwrvgnd_1
XTAP_2796 VGND VPWR sky130_fd_sc_hd__tapvpwrvgnd_1
XFILLER_0_200_655 VGND VGND VPWR VPWR sky130_fd_sc_hd__decap_4
XTAP_2785 VGND VPWR sky130_fd_sc_hd__tapvpwrvgnd_1
XFILLER_0_6_109 VPWR VGND VPWR VGND sky130_ef_sc_hd__decap_12
XFILLER_0_103_47 VGND VGND VPWR VPWR sky130_fd_sc_hd__decap_3
XFILLER_0_113_629 VPWR VGND VPWR VGND sky130_ef_sc_hd__decap_12
XFILLER_0_88_27 VGND VGND VPWR VPWR sky130_fd_sc_hd__fill_1
XFILLER_0_106_681 VPWR VGND VPWR VGND sky130_ef_sc_hd__decap_12
XFILLER_0_11_605 VPWR VGND VPWR VGND sky130_ef_sc_hd__decap_12
XFILLER_0_88_49 VGND VGND VPWR VPWR sky130_fd_sc_hd__fill_1
XFILLER_0_112_139 VGND VGND VPWR VPWR sky130_fd_sc_hd__fill_1
XFILLER_0_220_1317 VPWR VGND VPWR VGND sky130_ef_sc_hd__decap_12
XFILLER_0_195_39 VGND VGND VPWR VPWR sky130_fd_sc_hd__decap_8
XFILLER_0_177_1249 VGND VGND VPWR VPWR sky130_fd_sc_hd__decap_4
XFILLER_0_49_9 VGND VGND VPWR VPWR sky130_fd_sc_hd__fill_2
XFILLER_0_211_909 VPWR VGND VPWR VGND sky130_ef_sc_hd__decap_12
XFILLER_0_78_605 VPWR VGND VPWR VGND sky130_ef_sc_hd__decap_12
XFILLER_0_114_1233 VPWR VGND VPWR VGND sky130_ef_sc_hd__decap_12
XFILLER_0_4_1317 VPWR VGND VPWR VGND sky130_ef_sc_hd__decap_12
XFILLER_0_6_643 VGND VGND VPWR VPWR sky130_fd_sc_hd__fill_1
XFILLER_0_11_1249 VGND VGND VPWR VPWR sky130_fd_sc_hd__decap_4
XFILLER_0_104_629 VPWR VGND VPWR VGND sky130_ef_sc_hd__decap_12
XFILLER_0_82_3 VPWR VGND VPWR VGND sky130_ef_sc_hd__decap_12
XFILLER_0_2_1085 VGND VGND VPWR VPWR sky130_fd_sc_hd__decap_6
XFILLER_0_108_1037 VPWR VGND VPWR VGND sky130_ef_sc_hd__decap_12
XFILLER_0_2_893 VPWR VGND VPWR VGND sky130_ef_sc_hd__decap_12
XFILLER_0_111_161 VGND VGND VPWR VPWR sky130_fd_sc_hd__decap_6
XFILLER_0_160_1275 VGND VGND VPWR VPWR sky130_fd_sc_hd__decap_6
XFILLER_0_121_1237 VPWR VGND VPWR VGND sky130_ef_sc_hd__decap_12
XFILLER_0_214_725 VPWR VGND VPWR VGND sky130_ef_sc_hd__decap_12
XFILLER_0_214_769 VPWR VGND VPWR VGND sky130_ef_sc_hd__decap_12
XTAP_2015 VGND VPWR sky130_fd_sc_hd__tapvpwrvgnd_1
XFILLER_0_69_605 VPWR VGND VPWR VGND sky130_ef_sc_hd__decap_12
XTAP_2004 VGND VPWR sky130_fd_sc_hd__tapvpwrvgnd_1
XFILLER_0_213_279 VGND VGND VPWR VPWR sky130_fd_sc_hd__fill_1
XTAP_2037 VGND VPWR sky130_fd_sc_hd__tapvpwrvgnd_1
XTAP_2059 VGND VPWR sky130_fd_sc_hd__tapvpwrvgnd_1
XTAP_1303 VGND VPWR sky130_fd_sc_hd__tapvpwrvgnd_1
XTAP_1314 VGND VPWR sky130_fd_sc_hd__tapvpwrvgnd_1
XTAP_2026 VGND VPWR sky130_fd_sc_hd__tapvpwrvgnd_1
XTAP_2048 VGND VPWR sky130_fd_sc_hd__tapvpwrvgnd_1
XFILLER_0_210_953 VGND VGND VPWR VPWR sky130_fd_sc_hd__fill_2
XFILLER_0_194_643 VPWR VGND VPWR VGND sky130_ef_sc_hd__decap_12
XTAP_1325 VGND VPWR sky130_fd_sc_hd__tapvpwrvgnd_1
XTAP_1336 VGND VPWR sky130_fd_sc_hd__tapvpwrvgnd_1
XTAP_1347 VGND VPWR sky130_fd_sc_hd__tapvpwrvgnd_1
XFILLER_0_84_619 VPWR VGND VPWR VGND sky130_ef_sc_hd__decap_12
XFILLER_0_210_997 VGND VGND VPWR VPWR sky130_fd_sc_hd__fill_1
XTAP_1369 VGND VPWR sky130_fd_sc_hd__tapvpwrvgnd_1
XTAP_1358 VGND VPWR sky130_fd_sc_hd__tapvpwrvgnd_1
XFILLER_0_108_979 VGND VGND VPWR VPWR sky130_fd_sc_hd__fill_1
XFILLER_0_27_1201 VPWR VGND VPWR VGND sky130_ef_sc_hd__decap_12
XANTENNA_input66_A psum_col1_in[0] VGND VGND VPWR VPWR sky130_fd_sc_hd__diode_2
XFILLER_0_60_593 VPWR VGND VPWR VGND sky130_ef_sc_hd__decap_12
XFILLER_0_66_1283 VPWR VGND VPWR VGND sky130_ef_sc_hd__decap_12
XFILLER_0_27_1267 VPWR VGND VPWR VGND sky130_ef_sc_hd__decap_12
XFILLER_0_217_541 VPWR VGND VPWR VGND sky130_ef_sc_hd__decap_12
XFILLER_0_74_29 VPWR VGND VPWR VGND sky130_ef_sc_hd__decap_12
XFILLER_0_217_585 VPWR VGND VPWR VGND sky130_ef_sc_hd__decap_12
XFILLER_0_137_1255 VPWR VGND VPWR VGND sky130_ef_sc_hd__decap_12
XFILLER_0_213_1121 VPWR VGND VPWR VGND sky130_ef_sc_hd__decap_12
XTAP_2560 VGND VPWR sky130_fd_sc_hd__tapvpwrvgnd_1
XTAP_2571 VGND VPWR sky130_fd_sc_hd__tapvpwrvgnd_1
XFILLER_0_34_1227 VPWR VGND VPWR VGND sky130_ef_sc_hd__decap_12
XTAP_2582 VGND VPWR sky130_fd_sc_hd__tapvpwrvgnd_1
XTAP_2593 VGND VPWR sky130_fd_sc_hd__tapvpwrvgnd_1
XTAP_1870 VGND VPWR sky130_fd_sc_hd__tapvpwrvgnd_1
XFILLER_0_114_57 VPWR VGND VPWR VGND sky130_ef_sc_hd__decap_12
XTAP_1881 VGND VPWR sky130_fd_sc_hd__tapvpwrvgnd_1
XTAP_1892 VGND VPWR sky130_fd_sc_hd__tapvpwrvgnd_1
XFILLER_0_83_641 VGND VGND VPWR VPWR sky130_fd_sc_hd__decap_4
XFILLER_0_99_15 VPWR VGND VPWR VGND sky130_ef_sc_hd__decap_12
XFILLER_0_109_1313 VPWR VGND VPWR VGND sky130_ef_sc_hd__decap_12
XFILLER_0_183_1253 VGND VGND VPWR VPWR sky130_fd_sc_hd__fill_1
XFILLER_0_114_949 VGND VGND VPWR VPWR sky130_fd_sc_hd__decap_3
XFILLER_0_51_593 VPWR VGND VPWR VGND sky130_ef_sc_hd__decap_12
XFILLER_0_45_1323 VPWR VGND VPWR VGND sky130_ef_sc_hd__decap_12
XFILLER_0_80_1225 VGND VGND VPWR VPWR sky130_fd_sc_hd__fill_1
XFILLER_0_224_1261 VPWR VGND VPWR VGND sky130_ef_sc_hd__decap_12
XFILLER_0_2_189 VGND VGND VPWR VPWR sky130_fd_sc_hd__decap_6
XFILLER_0_220_1147 VGND VGND VPWR VPWR sky130_fd_sc_hd__fill_1
XFILLER_0_48_41 VGND VGND VPWR VPWR sky130_fd_sc_hd__decap_8
XFILLER_0_120_1281 VGND VGND VPWR VPWR sky130_fd_sc_hd__fill_1
XFILLER_0_155_1311 VPWR VGND VPWR VGND sky130_ef_sc_hd__decap_12
XFILLER_0_190_1213 VPWR VGND VPWR VGND sky130_ef_sc_hd__decap_12
XFILLER_0_116_1339 VGND VGND VPWR VPWR sky130_fd_sc_hd__decap_4
XFILLER_0_91_1343 VGND VGND VPWR VPWR sky130_fd_sc_hd__fill_1
XFILLER_0_210_249 VGND VGND VPWR VPWR sky130_fd_sc_hd__decap_3
XFILLER_0_66_619 VPWR VGND VPWR VGND sky130_ef_sc_hd__decap_12
XPHY_408 VGND VGND VPWR VPWR sky130_fd_sc_hd__decap_3
XFILLER_0_176_643 VPWR VGND VPWR VGND sky130_ef_sc_hd__decap_12
XPHY_419 VGND VGND VPWR VPWR sky130_fd_sc_hd__decap_3
XFILLER_0_8_1283 VPWR VGND VPWR VGND sky130_ef_sc_hd__decap_12
XPHY_1018 VGND VGND VPWR VPWR sky130_fd_sc_hd__decap_3
XPHY_1007 VGND VGND VPWR VPWR sky130_fd_sc_hd__decap_3
XPHY_1029 VGND VGND VPWR VPWR sky130_fd_sc_hd__decap_3
XFILLER_0_4_1147 VGND VGND VPWR VPWR sky130_fd_sc_hd__fill_1
XFILLER_0_108_209 VPWR VGND VPWR VGND sky130_ef_sc_hd__decap_12
XFILLER_0_162_1337 VGND VGND VPWR VPWR sky130_fd_sc_hd__fill_1
XFILLER_0_203_1323 VGND VGND VPWR VPWR sky130_fd_sc_hd__decap_8
XFILLER_0_42_593 VPWR VGND VPWR VGND sky130_ef_sc_hd__decap_12
XFILLER_0_219_839 VGND VGND VPWR VPWR sky130_fd_sc_hd__fill_1
XFILLER_0_100_643 VPWR VGND VPWR VGND sky130_ef_sc_hd__decap_12
XFILLER_0_214_533 VPWR VGND VPWR VGND sky130_ef_sc_hd__decap_12
XFILLER_0_226_393 VGND VGND VPWR VPWR sky130_fd_sc_hd__decap_4
XFILLER_0_57_1249 VGND VGND VPWR VPWR sky130_fd_sc_hd__decap_4
XANTENNA_input120_A w01[12] VGND VGND VPWR VPWR sky130_fd_sc_hd__diode_2
XPHY_920 VGND VGND VPWR VPWR sky130_fd_sc_hd__decap_3
XPHY_942 VGND VGND VPWR VPWR sky130_fd_sc_hd__decap_3
XPHY_931 VGND VGND VPWR VPWR sky130_fd_sc_hd__decap_3
XPHY_953 VGND VGND VPWR VPWR sky130_fd_sc_hd__decap_3
XFILLER_0_65_641 VGND VGND VPWR VPWR sky130_fd_sc_hd__decap_4
XPHY_997 VGND VGND VPWR VPWR sky130_fd_sc_hd__decap_3
XPHY_986 VGND VGND VPWR VPWR sky130_fd_sc_hd__decap_3
XPHY_975 VGND VGND VPWR VPWR sky130_fd_sc_hd__decap_3
XFILLER_0_167_1237 VPWR VGND VPWR VGND sky130_ef_sc_hd__decap_12
XPHY_964 VGND VGND VPWR VPWR sky130_fd_sc_hd__decap_3
XFILLER_0_208_1201 VPWR VGND VPWR VGND sky130_ef_sc_hd__decap_12
XFILLER_0_80_655 VGND VGND VPWR VPWR sky130_fd_sc_hd__decap_4
XFILLER_0_100_15 VPWR VGND VPWR VGND sky130_ef_sc_hd__decap_12
XFILLER_0_104_993 VPWR VGND VPWR VGND sky130_ef_sc_hd__decap_12
XFILLER_0_33_593 VPWR VGND VPWR VGND sky130_ef_sc_hd__decap_12
XFILLER_0_225_809 VPWR VGND VPWR VGND sky130_ef_sc_hd__decap_12
XFILLER_0_85_39 VGND VGND VPWR VPWR sky130_fd_sc_hd__decap_8
XFILLER_0_218_861 VGND VGND VPWR VPWR sky130_fd_sc_hd__decap_6
XFILLER_0_40_1275 VGND VGND VPWR VPWR sky130_fd_sc_hd__decap_6
XFILLER_0_109_57 VPWR VGND VPWR VGND sky130_ef_sc_hd__decap_12
XFILLER_0_217_393 VPWR VGND VPWR VGND sky130_ef_sc_hd__decap_12
XFILLER_0_192_29 VPWR VGND VPWR VGND sky130_ef_sc_hd__decap_12
XFILLER_0_220_525 VGND VGND VPWR VPWR sky130_fd_sc_hd__decap_6
XFILLER_0_48_619 VPWR VGND VPWR VGND sky130_ef_sc_hd__decap_12
XFILLER_0_220_569 VPWR VGND VPWR VGND sky130_ef_sc_hd__decap_12
XFILLER_0_158_643 VPWR VGND VPWR VGND sky130_ef_sc_hd__decap_12
XTAP_2390 VGND VPWR sky130_fd_sc_hd__tapvpwrvgnd_1
XFILLER_0_150_1263 VPWR VGND VPWR VGND sky130_ef_sc_hd__decap_12
XFILLER_0_111_1225 VGND VGND VPWR VPWR sky130_fd_sc_hd__decap_6
XFILLER_0_111_1269 VPWR VGND VPWR VGND sky130_ef_sc_hd__decap_12
XFILLER_0_7_237 VPWR VGND VPWR VGND sky130_ef_sc_hd__decap_12
XANTENNA_u_pe01_weight_in[2] net125 VGND VGND VPWR VPWR sky130_fd_sc_hd__diode_2
XFILLER_0_109_1121 VPWR VGND VPWR VGND sky130_ef_sc_hd__decap_12
XFILLER_0_114_713 VPWR VGND VPWR VGND sky130_ef_sc_hd__decap_12
XFILLER_0_71_655 VGND VGND VPWR VPWR sky130_fd_sc_hd__fill_2
XFILLER_0_114_757 VPWR VGND VPWR VGND sky130_ef_sc_hd__decap_12
XFILLER_0_113_223 VGND VGND VPWR VPWR sky130_fd_sc_hd__fill_1
XFILLER_0_105_1007 VGND VGND VPWR VPWR sky130_fd_sc_hd__fill_1
XFILLER_0_24_593 VPWR VGND VPWR VGND sky130_ef_sc_hd__decap_12
XFILLER_0_224_1091 VGND VGND VPWR VPWR sky130_fd_sc_hd__fill_1
XANTENNA_u_pe00_act_in[7] net14 VGND VGND VPWR VPWR sky130_fd_sc_hd__diode_2
XFILLER_0_122_1343 VGND VGND VPWR VPWR sky130_fd_sc_hd__fill_1
XFILLER_0_166_41 VGND VGND VPWR VPWR sky130_fd_sc_hd__decap_8
XFILLER_0_192_1319 VPWR VGND VPWR VGND sky130_ef_sc_hd__decap_12
XFILLER_0_211_503 VGND VGND VPWR VPWR sky130_fd_sc_hd__fill_1
XFILLER_0_223_385 VGND VGND VPWR VPWR sky130_fd_sc_hd__decap_6
XPHY_205 VGND VGND VPWR VPWR sky130_fd_sc_hd__decap_3
XPHY_216 VGND VGND VPWR VPWR sky130_fd_sc_hd__decap_3
XFILLER_0_17_1255 VPWR VGND VPWR VGND sky130_ef_sc_hd__decap_12
XFILLER_0_109_529 VPWR VGND VPWR VGND sky130_ef_sc_hd__decap_12
XPHY_238 VGND VGND VPWR VPWR sky130_fd_sc_hd__decap_3
XPHY_227 VGND VGND VPWR VPWR sky130_fd_sc_hd__decap_3
XFILLER_0_47_641 VGND VGND VPWR VPWR sky130_fd_sc_hd__decap_4
XPHY_249 VGND VGND VPWR VPWR sky130_fd_sc_hd__decap_3
XFILLER_0_201_47 VGND VGND VPWR VPWR sky130_fd_sc_hd__decap_3
XFILLER_0_62_655 VGND VGND VPWR VPWR sky130_fd_sc_hd__decap_4
XFILLER_0_166_1281 VGND VGND VPWR VPWR sky130_fd_sc_hd__fill_1
XFILLER_0_15_593 VPWR VGND VPWR VGND sky130_ef_sc_hd__decap_12
XFILLER_0_63_1253 VGND VGND VPWR VPWR sky130_fd_sc_hd__fill_1
Xu_pe11 VGND VPWR act_10_out_11_in\[0\] act_10_out_11_in\[10\] act_10_out_11_in\[11\]
+ act_10_out_11_in\[12\] act_10_out_11_in\[13\] act_10_out_11_in\[14\] act_10_out_11_in\[15\]
+ act_10_out_11_in\[1\] act_10_out_11_in\[2\] act_10_out_11_in\[3\] act_10_out_11_in\[4\]
+ act_10_out_11_in\[5\] act_10_out_11_in\[6\] act_10_out_11_in\[7\] act_10_out_11_in\[8\]
+ act_10_out_11_in\[9\] u_pe11/act_out[0] u_pe11/act_out[10] u_pe11/act_out[11] u_pe11/act_out[12]
+ u_pe11/act_out[13] u_pe11/act_out[14] u_pe11/act_out[15] u_pe11/act_out[1] u_pe11/act_out[2]
+ u_pe11/act_out[3] u_pe11/act_out[4] u_pe11/act_out[5] u_pe11/act_out[6] u_pe11/act_out[7]
+ u_pe11/act_out[8] u_pe11/act_out[9] clknet_1_0__leaf_clk net33 psum_01_out_11_in\[0\]
+ psum_01_out_11_in\[10\] psum_01_out_11_in\[11\] psum_01_out_11_in\[12\] psum_01_out_11_in\[13\]
+ psum_01_out_11_in\[14\] psum_01_out_11_in\[15\] psum_01_out_11_in\[16\] psum_01_out_11_in\[17\]
+ psum_01_out_11_in\[18\] psum_01_out_11_in\[19\] psum_01_out_11_in\[1\] psum_01_out_11_in\[20\]
+ psum_01_out_11_in\[21\] psum_01_out_11_in\[22\] psum_01_out_11_in\[23\] psum_01_out_11_in\[24\]
+ psum_01_out_11_in\[25\] psum_01_out_11_in\[26\] psum_01_out_11_in\[27\] psum_01_out_11_in\[28\]
+ psum_01_out_11_in\[29\] psum_01_out_11_in\[2\] psum_01_out_11_in\[30\] psum_01_out_11_in\[31\]
+ psum_01_out_11_in\[3\] psum_01_out_11_in\[4\] psum_01_out_11_in\[5\] psum_01_out_11_in\[6\]
+ psum_01_out_11_in\[7\] psum_01_out_11_in\[8\] psum_01_out_11_in\[9\] net197 net198
+ net199 net200 net201 net202 net203 net204 net205 net206 net207 net208 net209 net210
+ net211 net212 net213 net214 net215 net216 net217 net218 net219 net220 net221 net222
+ net223 net224 net225 net226 net227 net228 net98 valid_10_out_11_in net230 net149
+ net150 net151 net152 net153 net154 net155 net156 net157 net158 net159 net160 net161
+ net162 net163 net164 processing_element
Xu_pe00 VGND VPWR net1 net2 net3 net4 net5 net6 net7 net8 net9 net10 net11 net12 net13
+ net14 net15 net16 act_00_out_01_in\[0\] act_00_out_01_in\[10\] act_00_out_01_in\[11\]
+ act_00_out_01_in\[12\] act_00_out_01_in\[13\] act_00_out_01_in\[14\] act_00_out_01_in\[15\]
+ act_00_out_01_in\[1\] act_00_out_01_in\[2\] act_00_out_01_in\[3\] act_00_out_01_in\[4\]
+ act_00_out_01_in\[5\] act_00_out_01_in\[6\] act_00_out_01_in\[7\] act_00_out_01_in\[8\]
+ act_00_out_01_in\[9\] clknet_1_1__leaf_clk net33 net34 net35 net36 net37 net38 net39
+ net40 net41 net42 net43 net44 net45 net46 net47 net48 net49 net50 net51 net52 net53
+ net54 net55 net56 net57 net58 net59 net60 net61 net62 net63 net64 net65 psum_00_out_10_in\[0\]
+ psum_00_out_10_in\[10\] psum_00_out_10_in\[11\] psum_00_out_10_in\[12\] psum_00_out_10_in\[13\]
+ psum_00_out_10_in\[14\] psum_00_out_10_in\[15\] psum_00_out_10_in\[16\] psum_00_out_10_in\[17\]
+ psum_00_out_10_in\[18\] psum_00_out_10_in\[19\] psum_00_out_10_in\[1\] psum_00_out_10_in\[20\]
+ psum_00_out_10_in\[21\] psum_00_out_10_in\[22\] psum_00_out_10_in\[23\] psum_00_out_10_in\[24\]
+ psum_00_out_10_in\[25\] psum_00_out_10_in\[26\] psum_00_out_10_in\[27\] psum_00_out_10_in\[28\]
+ psum_00_out_10_in\[29\] psum_00_out_10_in\[2\] psum_00_out_10_in\[30\] psum_00_out_10_in\[31\]
+ psum_00_out_10_in\[3\] psum_00_out_10_in\[4\] psum_00_out_10_in\[5\] psum_00_out_10_in\[6\]
+ psum_00_out_10_in\[7\] psum_00_out_10_in\[8\] psum_00_out_10_in\[9\] net98 net99
+ valid_00_out_01_in net101 net102 net103 net104 net105 net106 net107 net108 net109
+ net110 net111 net112 net113 net114 net115 net116 processing_element
XFILLER_0_215_853 VPWR VGND VPWR VGND sky130_ef_sc_hd__decap_12
XANTENNA_input29_A act_row1_in[6] VGND VGND VPWR VPWR sky130_fd_sc_hd__diode_2
XFILLER_0_215_897 VPWR VGND VPWR VGND sky130_ef_sc_hd__decap_12
XFILLER_0_214_363 VGND VGND VPWR VPWR sky130_fd_sc_hd__fill_1
XFILLER_0_134_1225 VGND VGND VPWR VPWR sky130_fd_sc_hd__fill_1
XFILLER_0_35_1311 VPWR VGND VPWR VGND sky130_ef_sc_hd__decap_12
XFILLER_0_70_1213 VPWR VGND VPWR VGND sky130_ef_sc_hd__decap_12
XFILLER_0_210_1135 VPWR VGND VPWR VGND sky130_ef_sc_hd__decap_12
XFILLER_0_224_9 VGND VGND VPWR VPWR sky130_fd_sc_hd__fill_2
XPHY_750 VGND VGND VPWR VPWR sky130_fd_sc_hd__decap_3
XPHY_761 VGND VGND VPWR VPWR sky130_fd_sc_hd__decap_3
XPHY_772 VGND VGND VPWR VPWR sky130_fd_sc_hd__decap_3
XFILLER_0_170_605 VPWR VGND VPWR VGND sky130_ef_sc_hd__decap_12
XPHY_794 VGND VGND VPWR VPWR sky130_fd_sc_hd__decap_3
XPHY_783 VGND VGND VPWR VPWR sky130_fd_sc_hd__decap_3
XFILLER_0_53_655 VGND VGND VPWR VPWR sky130_fd_sc_hd__fill_2
XFILLER_0_180_1201 VPWR VGND VPWR VGND sky130_ef_sc_hd__decap_12
XFILLER_0_145_1343 VGND VGND VPWR VPWR sky130_fd_sc_hd__fill_1
XFILLER_0_105_6 VGND VGND VPWR VPWR sky130_fd_sc_hd__fill_2
XFILLER_0_111_69 VPWR VGND VPWR VGND sky130_ef_sc_hd__decap_12
XFILLER_0_111_727 VGND VGND VPWR VPWR sky130_fd_sc_hd__fill_1
XFILLER_0_221_1231 VGND VGND VPWR VPWR sky130_fd_sc_hd__fill_1
XFILLER_0_96_27 VGND VGND VPWR VPWR sky130_fd_sc_hd__fill_1
XFILLER_0_96_49 VGND VGND VPWR VPWR sky130_fd_sc_hd__fill_1
XFILLER_0_42_1337 VGND VGND VPWR VPWR sky130_fd_sc_hd__fill_1
XFILLER_0_225_617 VPWR VGND VPWR VGND sky130_ef_sc_hd__decap_12
XFILLER_0_188_3 VPWR VGND VPWR VGND sky130_ef_sc_hd__decap_12
XFILLER_0_31_9 VGND VGND VPWR VPWR sky130_fd_sc_hd__fill_2
XFILLER_0_136_22 VGND VGND VPWR VPWR sky130_fd_sc_hd__decap_6
XFILLER_0_220_333 VPWR VGND VPWR VGND sky130_ef_sc_hd__decap_12
XFILLER_0_215_1057 VGND VGND VPWR VPWR sky130_fd_sc_hd__decap_6
XFILLER_0_221_889 VGND VGND VPWR VPWR sky130_fd_sc_hd__decap_6
XFILLER_0_220_377 VPWR VGND VPWR VGND sky130_ef_sc_hd__decap_12
XFILLER_0_29_641 VGND VGND VPWR VPWR sky130_fd_sc_hd__decap_4
XFILLER_0_5_1231 VGND VGND VPWR VPWR sky130_fd_sc_hd__fill_1
XFILLER_0_111_1033 VPWR VGND VPWR VGND sky130_ef_sc_hd__decap_12
XFILLER_0_111_1077 VPWR VGND VPWR VGND sky130_ef_sc_hd__decap_12
XFILLER_0_161_605 VPWR VGND VPWR VGND sky130_ef_sc_hd__decap_12
XFILLER_0_44_655 VGND VGND VPWR VPWR sky130_fd_sc_hd__decap_4
XFILLER_0_226_1131 VGND VGND VPWR VPWR sky130_fd_sc_hd__fill_2
XFILLER_0_47_1237 VPWR VGND VPWR VGND sky130_ef_sc_hd__decap_12
XFILLER_0_86_1275 VGND VGND VPWR VPWR sky130_fd_sc_hd__decap_6
XFILLER_0_222_1017 VPWR VGND VPWR VGND sky130_ef_sc_hd__decap_12
XFILLER_0_3_273 VGND VGND VPWR VPWR sky130_fd_sc_hd__decap_6
XFILLER_0_200_1337 VGND VGND VPWR VPWR sky130_fd_sc_hd__fill_1
XFILLER_0_110_793 VPWR VGND VPWR VGND sky130_ef_sc_hd__decap_12
XFILLER_0_196_1263 VPWR VGND VPWR VGND sky130_ef_sc_hd__decap_12
XFILLER_0_215_105 VGND VGND VPWR VPWR sky130_fd_sc_hd__decap_6
XFILLER_0_215_149 VPWR VGND VPWR VGND sky130_ef_sc_hd__decap_12
XFILLER_0_157_1225 VPWR VGND VPWR VGND sky130_ef_sc_hd__decap_12
XFILLER_0_93_1213 VPWR VGND VPWR VGND sky130_ef_sc_hd__decap_12
XFILLER_0_223_193 VPWR VGND VPWR VGND sky130_ef_sc_hd__decap_12
XFILLER_0_93_1279 VPWR VGND VPWR VGND sky130_ef_sc_hd__decap_12
XFILLER_0_212_867 VGND VGND VPWR VPWR sky130_fd_sc_hd__fill_1
XFILLER_0_6_1017 VPWR VGND VPWR VGND sky130_ef_sc_hd__decap_12
XFILLER_0_133_1291 VPWR VGND VPWR VGND sky130_ef_sc_hd__decap_12
XFILLER_0_109_337 VPWR VGND VPWR VGND sky130_ef_sc_hd__decap_12
XFILLER_0_168_1343 VGND VGND VPWR VPWR sky130_fd_sc_hd__fill_1
XFILLER_0_152_605 VPWR VGND VPWR VGND sky130_ef_sc_hd__decap_12
XFILLER_0_35_655 VGND VGND VPWR VPWR sky130_fd_sc_hd__fill_2
XFILLER_0_30_1263 VPWR VGND VPWR VGND sky130_ef_sc_hd__decap_12
XFILLER_0_205_1237 VPWR VGND VPWR VGND sky130_ef_sc_hd__decap_12
XFILLER_0_207_617 VPWR VGND VPWR VGND sky130_ef_sc_hd__decap_12
XFILLER_0_140_1251 VPWR VGND VPWR VGND sky130_ef_sc_hd__decap_12
XFILLER_0_101_1213 VPWR VGND VPWR VGND sky130_ef_sc_hd__decap_12
XFILLER_0_175_1303 VGND VGND VPWR VPWR sky130_fd_sc_hd__decap_6
XFILLER_0_140_1295 VPWR VGND VPWR VGND sky130_ef_sc_hd__decap_12
XFILLER_0_101_1279 VPWR VGND VPWR VGND sky130_ef_sc_hd__decap_12
XFILLER_0_82_29 VPWR VGND VPWR VGND sky130_ef_sc_hd__decap_12
XFILLER_0_72_1319 VPWR VGND VPWR VGND sky130_ef_sc_hd__decap_12
XFILLER_0_143_605 VPWR VGND VPWR VGND sky130_ef_sc_hd__decap_12
XFILLER_0_5_505 VPWR VGND VPWR VGND sky130_ef_sc_hd__decap_12
XPHY_580 VGND VGND VPWR VPWR sky130_fd_sc_hd__decap_3
XFILLER_0_182_1307 VPWR VGND VPWR VGND sky130_ef_sc_hd__decap_12
XPHY_591 VGND VGND VPWR VPWR sky130_fd_sc_hd__decap_3
XFILLER_0_26_655 VGND VGND VPWR VPWR sky130_fd_sc_hd__decap_4
XANTENNA_u_pe01_psum_in[31] net90 VGND VGND VPWR VPWR sky130_fd_sc_hd__diode_2
XPHY_1190 VGND VGND VPWR VPWR sky130_fd_sc_hd__decap_3
XFILLER_0_41_647 VGND VGND VPWR VPWR sky130_fd_sc_hd__decap_8
XFILLER_0_103_3 VPWR VGND VPWR VGND sky130_ef_sc_hd__decap_12
XFILLER_0_223_1337 VGND VGND VPWR VPWR sky130_fd_sc_hd__decap_6
XFILLER_0_1_777 VGND VGND VPWR VPWR sky130_fd_sc_hd__decap_6
XFILLER_0_0_243 VGND VGND VPWR VPWR sky130_fd_sc_hd__fill_2
XFILLER_0_46_1281 VGND VGND VPWR VPWR sky130_fd_sc_hd__fill_1
XFILLER_0_0_265 VGND VGND VPWR VPWR sky130_fd_sc_hd__fill_2
XFILLER_0_147_10 VPWR VGND VPWR VGND sky130_ef_sc_hd__decap_12
XFILLER_0_56_41 VGND VGND VPWR VPWR sky130_fd_sc_hd__decap_8
XFILLER_0_213_609 VGND VGND VPWR VPWR sky130_fd_sc_hd__decap_6
XFILLER_0_225_447 VGND VGND VPWR VPWR sky130_fd_sc_hd__fill_1
XFILLER_0_217_1119 VGND VGND VPWR VPWR sky130_fd_sc_hd__fill_1
XFILLER_0_221_653 VPWR VGND VPWR VGND sky130_ef_sc_hd__decap_12
XFILLER_0_220_141 VPWR VGND VPWR VGND sky130_ef_sc_hd__decap_12
XFILLER_0_117_1253 VGND VGND VPWR VPWR sky130_fd_sc_hd__fill_1
XFILLER_0_221_697 VPWR VGND VPWR VGND sky130_ef_sc_hd__decap_12
XFILLER_0_14_1225 VGND VGND VPWR VPWR sky130_fd_sc_hd__fill_1
XFILLER_0_88_1337 VGND VGND VPWR VPWR sky130_fd_sc_hd__fill_1
XFILLER_0_134_605 VPWR VGND VPWR VGND sky130_ef_sc_hd__decap_12
XFILLER_0_106_307 VGND VGND VPWR VPWR sky130_fd_sc_hd__fill_1
XFILLER_0_124_1213 VPWR VGND VPWR VGND sky130_ef_sc_hd__decap_12
XFILLER_0_25_1343 VGND VGND VPWR VPWR sky130_fd_sc_hd__fill_1
XFILLER_0_60_1201 VPWR VGND VPWR VGND sky130_ef_sc_hd__decap_12
XFILLER_0_204_1281 VGND VGND VPWR VPWR sky130_fd_sc_hd__fill_1
XFILLER_0_159_1309 VGND VGND VPWR VPWR sky130_fd_sc_hd__fill_1
XFILLER_0_216_469 VGND VGND VPWR VPWR sky130_fd_sc_hd__decap_6
XFILLER_0_99_647 VPWR VGND VPWR VGND sky130_ef_sc_hd__decap_12
XTAP_2912 VGND VPWR sky130_fd_sc_hd__tapvpwrvgnd_1
XTAP_2901 VGND VPWR sky130_fd_sc_hd__tapvpwrvgnd_1
XTAP_2945 VGND VPWR sky130_fd_sc_hd__tapvpwrvgnd_1
XTAP_2934 VGND VPWR sky130_fd_sc_hd__tapvpwrvgnd_1
XTAP_2923 VGND VPWR sky130_fd_sc_hd__tapvpwrvgnd_1
XTAP_2956 VGND VPWR sky130_fd_sc_hd__tapvpwrvgnd_1
XFILLER_0_125_605 VPWR VGND VPWR VGND sky130_ef_sc_hd__decap_12
XANTENNA_input96_A psum_col1_in[8] VGND VGND VPWR VPWR sky130_fd_sc_hd__diode_2
XFILLER_0_192_593 VPWR VGND VPWR VGND sky130_ef_sc_hd__decap_12
XFILLER_0_109_167 VGND VGND VPWR VPWR sky130_fd_sc_hd__fill_1
XFILLER_0_140_619 VPWR VGND VPWR VGND sky130_ef_sc_hd__decap_12
XFILLER_0_23_647 VGND VGND VPWR VPWR sky130_fd_sc_hd__decap_8
XFILLER_0_105_373 VPWR VGND VPWR VGND sky130_ef_sc_hd__decap_12
XFILLER_0_179_1291 VPWR VGND VPWR VGND sky130_ef_sc_hd__decap_12
XFILLER_0_93_39 VGND VGND VPWR VPWR sky130_fd_sc_hd__decap_8
XFILLER_0_216_981 VPWR VGND VPWR VGND sky130_ef_sc_hd__decap_12
XFILLER_0_37_1225 VPWR VGND VPWR VGND sky130_ef_sc_hd__decap_12
XFILLER_0_76_1263 VPWR VGND VPWR VGND sky130_ef_sc_hd__decap_12
XFILLER_0_216_1141 VGND VGND VPWR VPWR sky130_fd_sc_hd__decap_6
XFILLER_0_216_1185 VPWR VGND VPWR VGND sky130_ef_sc_hd__decap_12
XFILLER_0_212_1005 VPWR VGND VPWR VGND sky130_ef_sc_hd__decap_12
XFILLER_0_212_1049 VPWR VGND VPWR VGND sky130_ef_sc_hd__decap_12
XFILLER_0_133_34 VPWR VGND VPWR VGND sky130_ef_sc_hd__decap_12
XFILLER_0_112_1161 VPWR VGND VPWR VGND sky130_ef_sc_hd__decap_12
XFILLER_0_186_1251 VPWR VGND VPWR VGND sky130_ef_sc_hd__decap_12
XFILLER_0_116_605 VPWR VGND VPWR VGND sky130_ef_sc_hd__decap_12
XFILLER_0_6_825 VPWR VGND VPWR VGND sky130_ef_sc_hd__decap_12
XFILLER_0_183_593 VPWR VGND VPWR VGND sky130_ef_sc_hd__decap_12
XFILLER_0_147_1213 VPWR VGND VPWR VGND sky130_ef_sc_hd__decap_12
XFILLER_0_5_335 VGND VGND VPWR VPWR sky130_fd_sc_hd__fill_1
XFILLER_0_6_869 VPWR VGND VPWR VGND sky130_ef_sc_hd__decap_12
XFILLER_0_13_1291 VPWR VGND VPWR VGND sky130_ef_sc_hd__decap_12
XFILLER_0_83_1201 VPWR VGND VPWR VGND sky130_ef_sc_hd__decap_12
XFILLER_0_186_1295 VPWR VGND VPWR VGND sky130_ef_sc_hd__decap_12
XANTENNA_u_pe01_psum_in[14] net71 VGND VGND VPWR VPWR sky130_fd_sc_hd__diode_2
XFILLER_0_147_1279 VPWR VGND VPWR VGND sky130_ef_sc_hd__decap_12
XFILLER_0_112_811 VGND VGND VPWR VPWR sky130_fd_sc_hd__fill_1
XFILLER_0_48_1343 VGND VGND VPWR VPWR sky130_fd_sc_hd__fill_1
XFILLER_0_223_1101 VPWR VGND VPWR VGND sky130_ef_sc_hd__decap_12
XFILLER_0_77_6 VGND VGND VPWR VPWR sky130_fd_sc_hd__fill_2
XFILLER_0_83_1267 VPWR VGND VPWR VGND sky130_ef_sc_hd__decap_12
XFILLER_0_223_1145 VPWR VGND VPWR VGND sky130_ef_sc_hd__decap_12
XFILLER_0_1_541 VPWR VGND VPWR VGND sky130_ef_sc_hd__decap_12
XFILLER_0_223_1189 VPWR VGND VPWR VGND sky130_ef_sc_hd__decap_12
XFILLER_0_1_585 VPWR VGND VPWR VGND sky130_ef_sc_hd__decap_12
XFILLER_0_6_65 VPWR VGND VPWR VGND sky130_ef_sc_hd__decap_12
XFILLER_0_226_701 VGND VGND VPWR VPWR sky130_fd_sc_hd__decap_4
XFILLER_0_158_1331 VGND VGND VPWR VPWR sky130_fd_sc_hd__decap_6
XFILLER_0_193_1255 VPWR VGND VPWR VGND sky130_ef_sc_hd__decap_12
XFILLER_0_198_619 VPWR VGND VPWR VGND sky130_ef_sc_hd__decap_12
XFILLER_0_213_417 VPWR VGND VPWR VGND sky130_ef_sc_hd__decap_12
XFILLER_0_20_1251 VPWR VGND VPWR VGND sky130_ef_sc_hd__decap_12
XFILLER_0_174_41 VGND VGND VPWR VPWR sky130_fd_sc_hd__decap_8
XFILLER_0_154_1239 VPWR VGND VPWR VGND sky130_ef_sc_hd__decap_12
XTAP_2208 VGND VPWR sky130_fd_sc_hd__tapvpwrvgnd_1
XFILLER_0_20_1295 VPWR VGND VPWR VGND sky130_ef_sc_hd__decap_12
XFILLER_0_55_1303 VGND VGND VPWR VPWR sky130_fd_sc_hd__decap_6
XFILLER_0_222_973 VGND VGND VPWR VPWR sky130_fd_sc_hd__decap_6
XTAP_2219 VGND VPWR sky130_fd_sc_hd__tapvpwrvgnd_1
XFILLER_0_90_1227 VPWR VGND VPWR VGND sky130_ef_sc_hd__decap_12
XFILLER_0_96_617 VGND VGND VPWR VPWR sky130_fd_sc_hd__fill_1
XFILLER_0_221_461 VPWR VGND VPWR VGND sky130_ef_sc_hd__decap_12
XPHY_47 VGND VGND VPWR VPWR sky130_fd_sc_hd__decap_3
XPHY_14 VGND VGND VPWR VPWR sky130_fd_sc_hd__decap_3
XPHY_25 VGND VGND VPWR VPWR sky130_fd_sc_hd__decap_3
XPHY_36 VGND VGND VPWR VPWR sky130_fd_sc_hd__decap_3
XTAP_1518 VGND VPWR sky130_fd_sc_hd__tapvpwrvgnd_1
XFILLER_0_7_1145 VGND VGND VPWR VPWR sky130_fd_sc_hd__decap_3
XTAP_1507 VGND VPWR sky130_fd_sc_hd__tapvpwrvgnd_1
XTAP_1529 VGND VPWR sky130_fd_sc_hd__tapvpwrvgnd_1
XPHY_58 VGND VGND VPWR VPWR sky130_fd_sc_hd__decap_3
XFILLER_0_3_1009 VPWR VGND VPWR VGND sky130_ef_sc_hd__decap_12
XPHY_69 VGND VGND VPWR VPWR sky130_fd_sc_hd__decap_3
XFILLER_0_9_641 VGND VGND VPWR VPWR sky130_fd_sc_hd__decap_4
XFILLER_0_7_1189 VPWR VGND VPWR VGND sky130_ef_sc_hd__decap_12
XFILLER_0_130_1283 VPWR VGND VPWR VGND sky130_ef_sc_hd__decap_12
XFILLER_0_165_1335 VGND VGND VPWR VPWR sky130_fd_sc_hd__decap_8
XFILLER_0_174_593 VPWR VGND VPWR VGND sky130_ef_sc_hd__decap_12
XFILLER_0_126_1319 VPWR VGND VPWR VGND sky130_ef_sc_hd__decap_12
XFILLER_0_122_619 VPWR VGND VPWR VGND sky130_ef_sc_hd__decap_12
XFILLER_0_206_1343 VGND VGND VPWR VPWR sky130_fd_sc_hd__fill_1
XFILLER_0_62_1307 VPWR VGND VPWR VGND sky130_ef_sc_hd__decap_12
XFILLER_0_20_617 VGND VGND VPWR VPWR sky130_fd_sc_hd__fill_1
XFILLER_0_114_181 VPWR VGND VPWR VGND sky130_ef_sc_hd__decap_12
XANTENNA_input150_A w11[10] VGND VGND VPWR VPWR sky130_fd_sc_hd__diode_2
XFILLER_0_216_233 VPWR VGND VPWR VGND sky130_ef_sc_hd__decap_12
XFILLER_0_216_277 VPWR VGND VPWR VGND sky130_ef_sc_hd__decap_12
XTAP_2720 VGND VPWR sky130_fd_sc_hd__tapvpwrvgnd_1
XFILLER_0_213_951 VGND VGND VPWR VPWR sky130_fd_sc_hd__fill_1
XFILLER_0_197_641 VGND VGND VPWR VPWR sky130_fd_sc_hd__decap_4
XFILLER_0_172_1339 VGND VGND VPWR VPWR sky130_fd_sc_hd__decap_4
XANTENNA_input11_A act_row0_in[4] VGND VGND VPWR VPWR sky130_fd_sc_hd__diode_2
XFILLER_0_87_617 VPWR VGND VPWR VGND sky130_ef_sc_hd__decap_12
XTAP_2753 VGND VPWR sky130_fd_sc_hd__tapvpwrvgnd_1
XTAP_2731 VGND VPWR sky130_fd_sc_hd__tapvpwrvgnd_1
XFILLER_0_213_1325 VPWR VGND VPWR VGND sky130_ef_sc_hd__decap_12
XTAP_2764 VGND VPWR sky130_fd_sc_hd__tapvpwrvgnd_1
XTAP_2742 VGND VPWR sky130_fd_sc_hd__tapvpwrvgnd_1
XTAP_2797 VGND VPWR sky130_fd_sc_hd__tapvpwrvgnd_1
XTAP_2775 VGND VPWR sky130_fd_sc_hd__tapvpwrvgnd_1
XTAP_2786 VGND VPWR sky130_fd_sc_hd__tapvpwrvgnd_1
XFILLER_0_103_15 VPWR VGND VPWR VGND sky130_ef_sc_hd__decap_12
XFILLER_0_165_593 VPWR VGND VPWR VGND sky130_ef_sc_hd__decap_12
XFILLER_0_106_693 VGND VGND VPWR VPWR sky130_fd_sc_hd__decap_6
XFILLER_0_3_839 VGND VGND VPWR VPWR sky130_fd_sc_hd__fill_1
XFILLER_0_121_641 VGND VGND VPWR VPWR sky130_fd_sc_hd__decap_4
XFILLER_0_11_617 VPWR VGND VPWR VGND sky130_ef_sc_hd__decap_12
XFILLER_0_105_181 VPWR VGND VPWR VGND sky130_ef_sc_hd__decap_12
XFILLER_0_220_1329 VPWR VGND VPWR VGND sky130_ef_sc_hd__decap_12
XFILLER_0_218_1203 VGND VGND VPWR VPWR sky130_fd_sc_hd__fill_1
XFILLER_0_39_1309 VGND VGND VPWR VPWR sky130_fd_sc_hd__fill_1
XFILLER_0_170_3 VPWR VGND VPWR VGND sky130_ef_sc_hd__decap_12
XFILLER_0_78_617 VGND VGND VPWR VPWR sky130_fd_sc_hd__fill_1
XFILLER_0_114_1201 VGND VGND VPWR VPWR sky130_fd_sc_hd__decap_3
XFILLER_0_114_1245 VPWR VGND VPWR VGND sky130_ef_sc_hd__decap_12
XFILLER_0_114_1289 VPWR VGND VPWR VGND sky130_ef_sc_hd__decap_12
XFILLER_0_4_1329 VPWR VGND VPWR VGND sky130_ef_sc_hd__decap_12
XFILLER_0_156_593 VPWR VGND VPWR VGND sky130_ef_sc_hd__decap_12
XFILLER_0_108_1005 VPWR VGND VPWR VGND sky130_ef_sc_hd__decap_12
XFILLER_0_6_699 VGND VGND VPWR VPWR sky130_fd_sc_hd__fill_1
XFILLER_0_108_1049 VPWR VGND VPWR VGND sky130_ef_sc_hd__decap_12
XFILLER_0_2_861 VGND VGND VPWR VPWR sky130_fd_sc_hd__decap_6
XFILLER_0_75_3 VPWR VGND VPWR VGND sky130_ef_sc_hd__decap_12
XFILLER_0_121_1249 VGND VGND VPWR VPWR sky130_fd_sc_hd__decap_4
XFILLER_0_1_393 VPWR VGND VPWR VGND sky130_ef_sc_hd__decap_12
XANTENNA_input3_A act_row0_in[11] VGND VGND VPWR VPWR sky130_fd_sc_hd__diode_2
XFILLER_0_226_586 VGND VGND VPWR VPWR sky130_fd_sc_hd__fill_2
XFILLER_0_214_737 VPWR VGND VPWR VGND sky130_ef_sc_hd__decap_12
XFILLER_0_213_225 VPWR VGND VPWR VGND sky130_ef_sc_hd__decap_12
XFILLER_0_179_641 VGND VGND VPWR VPWR sky130_fd_sc_hd__decap_4
XTAP_2016 VGND VPWR sky130_fd_sc_hd__tapvpwrvgnd_1
XFILLER_0_69_617 VPWR VGND VPWR VGND sky130_ef_sc_hd__decap_12
XFILLER_0_59_1291 VPWR VGND VPWR VGND sky130_ef_sc_hd__decap_12
XTAP_2005 VGND VPWR sky130_fd_sc_hd__tapvpwrvgnd_1
XFILLER_0_222_781 VPWR VGND VPWR VGND sky130_ef_sc_hd__decap_12
XFILLER_0_210_910 VPWR VGND VPWR VGND sky130_ef_sc_hd__decap_12
XTAP_2038 VGND VPWR sky130_fd_sc_hd__tapvpwrvgnd_1
XTAP_1304 VGND VPWR sky130_fd_sc_hd__tapvpwrvgnd_1
XTAP_2027 VGND VPWR sky130_fd_sc_hd__tapvpwrvgnd_1
XTAP_2049 VGND VPWR sky130_fd_sc_hd__tapvpwrvgnd_1
XFILLER_0_210_965 VGND VGND VPWR VPWR sky130_fd_sc_hd__decap_3
XTAP_1326 VGND VPWR sky130_fd_sc_hd__tapvpwrvgnd_1
XTAP_1315 VGND VPWR sky130_fd_sc_hd__tapvpwrvgnd_1
XTAP_1337 VGND VPWR sky130_fd_sc_hd__tapvpwrvgnd_1
XTAP_1348 VGND VPWR sky130_fd_sc_hd__tapvpwrvgnd_1
XFILLER_0_194_655 VGND VGND VPWR VPWR sky130_fd_sc_hd__decap_4
XTAP_1359 VGND VPWR sky130_fd_sc_hd__tapvpwrvgnd_1
XFILLER_0_108_925 VPWR VGND VPWR VGND sky130_ef_sc_hd__decap_12
XFILLER_0_92_631 VPWR VGND VPWR VGND sky130_ef_sc_hd__decap_12
XFILLER_0_220_13 VPWR VGND VPWR VGND sky130_ef_sc_hd__decap_12
XFILLER_0_147_593 VPWR VGND VPWR VGND sky130_ef_sc_hd__decap_12
XFILLER_0_66_1251 VPWR VGND VPWR VGND sky130_ef_sc_hd__decap_12
XFILLER_0_103_641 VGND VGND VPWR VPWR sky130_fd_sc_hd__decap_4
XFILLER_0_0_809 VGND VGND VPWR VPWR sky130_fd_sc_hd__decap_3
XFILLER_0_27_1213 VPWR VGND VPWR VGND sky130_ef_sc_hd__decap_12
XFILLER_0_66_1295 VPWR VGND VPWR VGND sky130_ef_sc_hd__decap_12
XANTENNA_input59_A psum_col0_in[3] VGND VGND VPWR VPWR sky130_fd_sc_hd__diode_2
XFILLER_0_27_1279 VPWR VGND VPWR VGND sky130_ef_sc_hd__decap_12
XFILLER_0_217_553 VGND VGND VPWR VPWR sky130_fd_sc_hd__decap_6
XFILLER_0_217_597 VPWR VGND VPWR VGND sky130_ef_sc_hd__decap_12
XFILLER_0_137_1201 VPWR VGND VPWR VGND sky130_ef_sc_hd__decap_12
XFILLER_0_176_1283 VPWR VGND VPWR VGND sky130_ef_sc_hd__decap_12
XFILLER_0_38_1331 VGND VGND VPWR VPWR sky130_fd_sc_hd__decap_6
XFILLER_0_137_1267 VPWR VGND VPWR VGND sky130_ef_sc_hd__decap_12
XANTENNA_output215_A net215 VGND VGND VPWR VPWR sky130_fd_sc_hd__diode_2
XFILLER_0_73_1255 VPWR VGND VPWR VGND sky130_ef_sc_hd__decap_12
XFILLER_0_213_1133 VPWR VGND VPWR VGND sky130_ef_sc_hd__decap_12
XTAP_2561 VGND VPWR sky130_fd_sc_hd__tapvpwrvgnd_1
XTAP_2550 VGND VPWR sky130_fd_sc_hd__tapvpwrvgnd_1
XTAP_2572 VGND VPWR sky130_fd_sc_hd__tapvpwrvgnd_1
XFILLER_0_34_1239 VPWR VGND VPWR VGND sky130_ef_sc_hd__decap_12
XFILLER_0_90_29 VPWR VGND VPWR VGND sky130_ef_sc_hd__decap_12
XFILLER_0_213_1177 VPWR VGND VPWR VGND sky130_ef_sc_hd__decap_12
XTAP_2583 VGND VPWR sky130_fd_sc_hd__tapvpwrvgnd_1
XFILLER_0_185_655 VGND VGND VPWR VPWR sky130_fd_sc_hd__fill_2
XTAP_2594 VGND VPWR sky130_fd_sc_hd__tapvpwrvgnd_1
XTAP_1860 VGND VPWR sky130_fd_sc_hd__tapvpwrvgnd_1
XTAP_1882 VGND VPWR sky130_fd_sc_hd__tapvpwrvgnd_1
XTAP_1871 VGND VPWR sky130_fd_sc_hd__tapvpwrvgnd_1
XTAP_1893 VGND VPWR sky130_fd_sc_hd__tapvpwrvgnd_1
XFILLER_0_114_69 VPWR VGND VPWR VGND sky130_ef_sc_hd__decap_12
XFILLER_0_138_593 VPWR VGND VPWR VGND sky130_ef_sc_hd__decap_12
XFILLER_0_99_27 VPWR VGND VPWR VGND sky130_ef_sc_hd__decap_12
XFILLER_0_113_405 VPWR VGND VPWR VGND sky130_ef_sc_hd__decap_12
XFILLER_0_109_1325 VPWR VGND VPWR VGND sky130_ef_sc_hd__decap_12
XFILLER_0_10_1283 VPWR VGND VPWR VGND sky130_ef_sc_hd__decap_12
XFILLER_0_144_1227 VPWR VGND VPWR VGND sky130_ef_sc_hd__decap_12
XFILLER_0_45_1335 VGND VGND VPWR VPWR sky130_fd_sc_hd__decap_8
XFILLER_0_113_449 VPWR VGND VPWR VGND sky130_ef_sc_hd__decap_12
XFILLER_0_224_1273 VPWR VGND VPWR VGND sky130_ef_sc_hd__decap_12
XFILLER_0_3_11 VPWR VGND VPWR VGND sky130_ef_sc_hd__decap_12
XFILLER_0_3_55 VGND VGND VPWR VPWR sky130_fd_sc_hd__fill_1
XFILLER_0_190_1225 VGND VGND VPWR VPWR sky130_fd_sc_hd__fill_1
XFILLER_0_155_1323 VPWR VGND VPWR VGND sky130_ef_sc_hd__decap_12
XFILLER_0_116_1307 VPWR VGND VPWR VGND sky130_ef_sc_hd__decap_12
XFILLER_0_91_1311 VPWR VGND VPWR VGND sky130_ef_sc_hd__decap_12
XFILLER_0_64_41 VGND VGND VPWR VPWR sky130_fd_sc_hd__decap_8
XFILLER_0_211_729 VPWR VGND VPWR VGND sky130_ef_sc_hd__decap_12
XFILLER_0_8_1251 VPWR VGND VPWR VGND sky130_ef_sc_hd__decap_12
XFILLER_0_52_1339 VGND VGND VPWR VPWR sky130_fd_sc_hd__decap_4
XFILLER_0_176_655 VGND VGND VPWR VPWR sky130_fd_sc_hd__decap_4
XPHY_409 VGND VGND VPWR VPWR sky130_fd_sc_hd__decap_3
XFILLER_0_8_1295 VPWR VGND VPWR VGND sky130_ef_sc_hd__decap_12
XPHY_1008 VGND VGND VPWR VPWR sky130_fd_sc_hd__decap_3
XPHY_1019 VGND VGND VPWR VPWR sky130_fd_sc_hd__decap_3
XFILLER_0_74_631 VPWR VGND VPWR VGND sky130_ef_sc_hd__decap_12
XFILLER_0_191_647 VPWR VGND VPWR VGND sky130_ef_sc_hd__decap_12
XFILLER_0_129_593 VPWR VGND VPWR VGND sky130_ef_sc_hd__decap_12
XFILLER_0_7_953 VPWR VGND VPWR VGND sky130_ef_sc_hd__decap_12
XFILLER_0_104_449 VPWR VGND VPWR VGND sky130_ef_sc_hd__decap_12
XFILLER_0_100_655 VGND VGND VPWR VPWR sky130_fd_sc_hd__decap_4
XFILLER_0_214_501 VPWR VGND VPWR VGND sky130_ef_sc_hd__decap_12
XFILLER_0_214_545 VPWR VGND VPWR VGND sky130_ef_sc_hd__decap_12
XFILLER_0_214_589 VPWR VGND VPWR VGND sky130_ef_sc_hd__decap_12
XFILLER_0_215_57 VPWR VGND VPWR VGND sky130_ef_sc_hd__decap_12
XANTENNA_input113_A w00[6] VGND VGND VPWR VPWR sky130_fd_sc_hd__diode_2
XFILLER_0_210_1317 VPWR VGND VPWR VGND sky130_ef_sc_hd__decap_12
XFILLER_0_167_655 VGND VGND VPWR VPWR sky130_fd_sc_hd__fill_2
XPHY_910 VGND VGND VPWR VPWR sky130_fd_sc_hd__decap_3
XPHY_921 VGND VGND VPWR VPWR sky130_fd_sc_hd__decap_3
XPHY_954 VGND VGND VPWR VPWR sky130_fd_sc_hd__decap_3
XPHY_943 VGND VGND VPWR VPWR sky130_fd_sc_hd__decap_3
XPHY_932 VGND VGND VPWR VPWR sky130_fd_sc_hd__decap_3
XPHY_976 VGND VGND VPWR VPWR sky130_fd_sc_hd__decap_3
XPHY_987 VGND VGND VPWR VPWR sky130_fd_sc_hd__decap_3
XPHY_965 VGND VGND VPWR VPWR sky130_fd_sc_hd__decap_3
XPHY_998 VGND VGND VPWR VPWR sky130_fd_sc_hd__decap_3
XFILLER_0_167_1249 VGND VGND VPWR VPWR sky130_fd_sc_hd__decap_4
XFILLER_0_108_755 VGND VGND VPWR VPWR sky130_fd_sc_hd__fill_1
XFILLER_0_208_1213 VPWR VGND VPWR VGND sky130_ef_sc_hd__decap_12
XFILLER_0_111_909 VPWR VGND VPWR VGND sky130_ef_sc_hd__decap_12
XFILLER_0_100_27 VGND VGND VPWR VPWR sky130_fd_sc_hd__fill_1
XFILLER_0_0_617 VGND VGND VPWR VPWR sky130_fd_sc_hd__fill_2
XFILLER_0_100_49 VGND VGND VPWR VPWR sky130_fd_sc_hd__fill_1
XFILLER_0_110_419 VGND VGND VPWR VPWR sky130_fd_sc_hd__fill_1
XFILLER_0_104_1233 VPWR VGND VPWR VGND sky130_ef_sc_hd__decap_12
XFILLER_0_224_309 VPWR VGND VPWR VGND sky130_ef_sc_hd__decap_12
XFILLER_0_217_361 VPWR VGND VPWR VGND sky130_ef_sc_hd__decap_12
XFILLER_0_109_69 VPWR VGND VPWR VGND sky130_ef_sc_hd__decap_12
XTAP_2380 VGND VPWR sky130_fd_sc_hd__tapvpwrvgnd_1
XFILLER_0_158_655 VGND VGND VPWR VPWR sky130_fd_sc_hd__decap_4
XTAP_2391 VGND VPWR sky130_fd_sc_hd__tapvpwrvgnd_1
XFILLER_0_150_1275 VGND VGND VPWR VPWR sky130_fd_sc_hd__decap_6
XFILLER_0_56_631 VPWR VGND VPWR VGND sky130_ef_sc_hd__decap_12
XFILLER_0_173_647 VGND VGND VPWR VPWR sky130_fd_sc_hd__decap_8
XTAP_1690 VGND VPWR sky130_fd_sc_hd__tapvpwrvgnd_1
XANTENNA_u_pe01_weight_in[1] net124 VGND VGND VPWR VPWR sky130_fd_sc_hd__diode_2
XFILLER_0_7_249 VGND VGND VPWR VPWR sky130_fd_sc_hd__decap_3
XFILLER_0_226_1335 VGND VGND VPWR VPWR sky130_fd_sc_hd__decap_3
XFILLER_0_226_1313 VGND VGND VPWR VPWR sky130_fd_sc_hd__decap_3
XFILLER_0_114_725 VGND VGND VPWR VPWR sky130_fd_sc_hd__decap_3
XFILLER_0_4_923 VGND VGND VPWR VPWR sky130_fd_sc_hd__fill_1
XFILLER_0_71_645 VGND VGND VPWR VPWR sky130_fd_sc_hd__fill_1
XFILLER_0_109_1133 VPWR VGND VPWR VGND sky130_ef_sc_hd__decap_12
XFILLER_0_114_769 VPWR VGND VPWR VGND sky130_ef_sc_hd__decap_12
XFILLER_0_109_1177 VPWR VGND VPWR VGND sky130_ef_sc_hd__decap_12
XFILLER_0_113_279 VGND VGND VPWR VPWR sky130_fd_sc_hd__fill_1
XANTENNA_u_pe00_act_in[6] net13 VGND VGND VPWR VPWR sky130_fd_sc_hd__diode_2
XFILLER_0_211_559 VGND VGND VPWR VPWR sky130_fd_sc_hd__fill_1
XFILLER_0_182_41 VGND VGND VPWR VPWR sky130_fd_sc_hd__decap_8
XFILLER_0_17_1201 VPWR VGND VPWR VGND sky130_ef_sc_hd__decap_12
XFILLER_0_149_655 VGND VGND VPWR VPWR sky130_fd_sc_hd__fill_2
XFILLER_0_17_1267 VPWR VGND VPWR VGND sky130_ef_sc_hd__decap_12
XPHY_206 VGND VGND VPWR VPWR sky130_fd_sc_hd__decap_3
XFILLER_0_56_1283 VPWR VGND VPWR VGND sky130_ef_sc_hd__decap_12
XPHY_239 VGND VGND VPWR VPWR sky130_fd_sc_hd__decap_3
XPHY_217 VGND VGND VPWR VPWR sky130_fd_sc_hd__decap_3
XPHY_228 VGND VGND VPWR VPWR sky130_fd_sc_hd__decap_3
XFILLER_0_201_15 VPWR VGND VPWR VGND sky130_ef_sc_hd__decap_12
XFILLER_0_127_1255 VPWR VGND VPWR VGND sky130_ef_sc_hd__decap_12
XFILLER_0_219_615 VGND VGND VPWR VPWR sky130_fd_sc_hd__fill_1
XFILLER_0_24_1227 VPWR VGND VPWR VGND sky130_ef_sc_hd__decap_12
Xu_pe01 VGND VPWR act_00_out_01_in\[0\] act_00_out_01_in\[10\] act_00_out_01_in\[11\]
+ act_00_out_01_in\[12\] act_00_out_01_in\[13\] act_00_out_01_in\[14\] act_00_out_01_in\[15\]
+ act_00_out_01_in\[1\] act_00_out_01_in\[2\] act_00_out_01_in\[3\] act_00_out_01_in\[4\]
+ act_00_out_01_in\[5\] act_00_out_01_in\[6\] act_00_out_01_in\[7\] act_00_out_01_in\[8\]
+ act_00_out_01_in\[9\] u_pe01/act_out[0] u_pe01/act_out[10] u_pe01/act_out[11] u_pe01/act_out[12]
+ u_pe01/act_out[13] u_pe01/act_out[14] u_pe01/act_out[15] u_pe01/act_out[1] u_pe01/act_out[2]
+ u_pe01/act_out[3] u_pe01/act_out[4] u_pe01/act_out[5] u_pe01/act_out[6] u_pe01/act_out[7]
+ u_pe01/act_out[8] u_pe01/act_out[9] clknet_1_1__leaf_clk net33 net66 net67 net68
+ net69 net70 net71 net72 net73 net74 net75 net76 net77 net78 net79 net80 net81 net82
+ net83 net84 net85 net86 net87 net88 net89 net90 net91 net92 net93 net94 net95 net96
+ net97 psum_01_out_11_in\[0\] psum_01_out_11_in\[10\] psum_01_out_11_in\[11\] psum_01_out_11_in\[12\]
+ psum_01_out_11_in\[13\] psum_01_out_11_in\[14\] psum_01_out_11_in\[15\] psum_01_out_11_in\[16\]
+ psum_01_out_11_in\[17\] psum_01_out_11_in\[18\] psum_01_out_11_in\[19\] psum_01_out_11_in\[1\]
+ psum_01_out_11_in\[20\] psum_01_out_11_in\[21\] psum_01_out_11_in\[22\] psum_01_out_11_in\[23\]
+ psum_01_out_11_in\[24\] psum_01_out_11_in\[25\] psum_01_out_11_in\[26\] psum_01_out_11_in\[27\]
+ psum_01_out_11_in\[28\] psum_01_out_11_in\[29\] psum_01_out_11_in\[2\] psum_01_out_11_in\[30\]
+ psum_01_out_11_in\[31\] psum_01_out_11_in\[3\] psum_01_out_11_in\[4\] psum_01_out_11_in\[5\]
+ psum_01_out_11_in\[6\] psum_01_out_11_in\[7\] psum_01_out_11_in\[8\] psum_01_out_11_in\[9\]
+ net98 valid_00_out_01_in net229 net117 net118 net119 net120 net121 net122 net123
+ net124 net125 net126 net127 net128 net129 net130 net131 net132 processing_element
XFILLER_0_98_1339 VGND VGND VPWR VPWR sky130_fd_sc_hd__decap_4
XFILLER_0_215_821 VPWR VGND VPWR VGND sky130_ef_sc_hd__decap_12
XFILLER_0_215_865 VPWR VGND VPWR VGND sky130_ef_sc_hd__decap_12
XFILLER_0_226_12 VGND VGND VPWR VPWR sky130_fd_sc_hd__fill_2
XFILLER_0_173_1253 VGND VGND VPWR VPWR sky130_fd_sc_hd__fill_1
XFILLER_0_35_1323 VPWR VGND VPWR VGND sky130_ef_sc_hd__decap_12
XFILLER_0_214_1261 VPWR VGND VPWR VGND sky130_ef_sc_hd__decap_12
XFILLER_0_70_1225 VGND VGND VPWR VPWR sky130_fd_sc_hd__fill_1
XFILLER_0_38_631 VPWR VGND VPWR VGND sky130_ef_sc_hd__decap_12
XFILLER_0_210_1147 VGND VGND VPWR VPWR sky130_fd_sc_hd__fill_1
XPHY_762 VGND VGND VPWR VPWR sky130_fd_sc_hd__decap_3
XPHY_751 VGND VGND VPWR VPWR sky130_fd_sc_hd__decap_3
XFILLER_0_155_647 VGND VGND VPWR VPWR sky130_fd_sc_hd__decap_8
XPHY_740 VGND VGND VPWR VPWR sky130_fd_sc_hd__decap_3
XFILLER_0_217_9 VGND VGND VPWR VPWR sky130_fd_sc_hd__fill_2
XPHY_784 VGND VGND VPWR VPWR sky130_fd_sc_hd__decap_3
XPHY_773 VGND VGND VPWR VPWR sky130_fd_sc_hd__decap_3
XFILLER_0_5_709 VPWR VGND VPWR VGND sky130_ef_sc_hd__decap_12
XPHY_795 VGND VGND VPWR VPWR sky130_fd_sc_hd__decap_3
XANTENNA_u_pe00_psum_in[31] net58 VGND VGND VPWR VPWR sky130_fd_sc_hd__diode_2
XFILLER_0_170_617 VGND VGND VPWR VPWR sky130_fd_sc_hd__fill_1
XFILLER_0_53_645 VGND VGND VPWR VPWR sky130_fd_sc_hd__fill_1
XFILLER_0_111_15 VPWR VGND VPWR VGND sky130_ef_sc_hd__decap_12
XFILLER_0_180_1213 VPWR VGND VPWR VGND sky130_ef_sc_hd__decap_12
XFILLER_0_145_1311 VPWR VGND VPWR VGND sky130_ef_sc_hd__decap_12
XFILLER_0_106_1317 VPWR VGND VPWR VGND sky130_ef_sc_hd__decap_12
XFILLER_0_81_1343 VGND VGND VPWR VPWR sky130_fd_sc_hd__fill_1
XFILLER_0_0_447 VGND VGND VPWR VPWR sky130_fd_sc_hd__fill_1
XFILLER_0_221_1287 VGND VGND VPWR VPWR sky130_fd_sc_hd__fill_1
XFILLER_0_225_629 VPWR VGND VPWR VGND sky130_ef_sc_hd__decap_12
XFILLER_0_218_681 VPWR VGND VPWR VGND sky130_ef_sc_hd__decap_12
XFILLER_0_224_139 VGND VGND VPWR VPWR sky130_fd_sc_hd__fill_1
XFILLER_0_191_1331 VGND VGND VPWR VPWR sky130_fd_sc_hd__fill_2
XFILLER_0_24_9 VGND VGND VPWR VPWR sky130_fd_sc_hd__fill_2
XFILLER_0_220_301 VGND VGND VPWR VPWR sky130_fd_sc_hd__decap_6
XFILLER_0_152_1337 VGND VGND VPWR VPWR sky130_fd_sc_hd__fill_1
XFILLER_0_220_345 VPWR VGND VPWR VGND sky130_ef_sc_hd__decap_12
XFILLER_0_220_389 VPWR VGND VPWR VGND sky130_ef_sc_hd__decap_12
XFILLER_0_111_1001 VGND VGND VPWR VPWR sky130_fd_sc_hd__decap_6
XFILLER_0_111_1045 VPWR VGND VPWR VGND sky130_ef_sc_hd__decap_12
XFILLER_0_5_1287 VGND VGND VPWR VPWR sky130_fd_sc_hd__fill_1
XFILLER_0_111_1089 VPWR VGND VPWR VGND sky130_ef_sc_hd__decap_12
XFILLER_0_161_617 VPWR VGND VPWR VGND sky130_ef_sc_hd__decap_12
XFILLER_0_226_1143 VGND VGND VPWR VPWR sky130_fd_sc_hd__decap_3
XFILLER_0_114_533 VPWR VGND VPWR VGND sky130_ef_sc_hd__decap_12
XFILLER_0_47_1249 VGND VGND VPWR VPWR sky130_fd_sc_hd__decap_4
XFILLER_0_226_1198 VGND VGND VPWR VPWR sky130_fd_sc_hd__decap_6
XFILLER_0_222_1029 VGND VGND VPWR VPWR sky130_fd_sc_hd__decap_6
XFILLER_0_0_981 VPWR VGND VPWR VGND sky130_ef_sc_hd__decap_12
XFILLER_0_196_1275 VGND VGND VPWR VPWR sky130_fd_sc_hd__decap_6
XFILLER_0_157_1237 VPWR VGND VPWR VGND sky130_ef_sc_hd__decap_12
XFILLER_0_212_813 VPWR VGND VPWR VGND sky130_ef_sc_hd__decap_12
XFILLER_0_93_1225 VPWR VGND VPWR VGND sky130_ef_sc_hd__decap_12
XFILLER_0_223_161 VGND VGND VPWR VPWR sky130_fd_sc_hd__decap_6
XFILLER_0_6_1029 VGND VGND VPWR VPWR sky130_fd_sc_hd__decap_6
XFILLER_0_109_305 VPWR VGND VPWR VGND sky130_ef_sc_hd__decap_12
XFILLER_0_137_647 VGND VGND VPWR VPWR sky130_fd_sc_hd__decap_8
XFILLER_0_109_349 VPWR VGND VPWR VGND sky130_ef_sc_hd__decap_12
XFILLER_0_152_617 VGND VGND VPWR VPWR sky130_fd_sc_hd__fill_1
XFILLER_0_35_645 VGND VGND VPWR VPWR sky130_fd_sc_hd__fill_1
XFILLER_0_30_1275 VGND VGND VPWR VPWR sky130_fd_sc_hd__decap_6
XFILLER_0_205_1249 VGND VGND VPWR VPWR sky130_fd_sc_hd__decap_4
XANTENNA_input41_A psum_col0_in[16] VGND VGND VPWR VPWR sky130_fd_sc_hd__diode_2
XFILLER_0_140_1263 VPWR VGND VPWR VGND sky130_ef_sc_hd__decap_12
XFILLER_0_207_629 VPWR VGND VPWR VGND sky130_ef_sc_hd__decap_12
XFILLER_0_101_1225 VPWR VGND VPWR VGND sky130_ef_sc_hd__decap_12
XFILLER_0_215_673 VPWR VGND VPWR VGND sky130_ef_sc_hd__decap_12
XFILLER_0_106_15 VPWR VGND VPWR VGND sky130_ef_sc_hd__decap_12
XFILLER_0_214_1091 VGND VGND VPWR VPWR sky130_fd_sc_hd__fill_1
XPHY_570 VGND VGND VPWR VPWR sky130_fd_sc_hd__decap_3
XFILLER_0_143_617 VPWR VGND VPWR VGND sky130_ef_sc_hd__decap_12
XFILLER_0_31_45 VGND VGND VPWR VPWR sky130_fd_sc_hd__decap_3
XFILLER_0_5_517 VPWR VGND VPWR VGND sky130_ef_sc_hd__decap_12
XPHY_581 VGND VGND VPWR VPWR sky130_fd_sc_hd__decap_3
XPHY_592 VGND VGND VPWR VPWR sky130_fd_sc_hd__decap_3
XPHY_1191 VGND VGND VPWR VPWR sky130_fd_sc_hd__decap_3
XANTENNA_u_pe01_psum_in[30] net89 VGND VGND VPWR VPWR sky130_fd_sc_hd__diode_2
XFILLER_0_182_1319 VPWR VGND VPWR VGND sky130_ef_sc_hd__decap_12
XPHY_1180 VGND VGND VPWR VPWR sky130_fd_sc_hd__decap_3
XFILLER_0_198_29 VPWR VGND VPWR VGND sky130_ef_sc_hd__decap_12
XFILLER_0_111_503 VGND VGND VPWR VPWR sky130_fd_sc_hd__fill_1
XFILLER_0_106_1147 VGND VGND VPWR VPWR sky130_fd_sc_hd__fill_1
XFILLER_0_147_22 VPWR VGND VPWR VGND sky130_ef_sc_hd__decap_12
XFILLER_0_212_109 VPWR VGND VPWR VGND sky130_ef_sc_hd__decap_12
XFILLER_0_221_665 VGND VGND VPWR VPWR sky130_fd_sc_hd__decap_6
XFILLER_0_156_1281 VGND VGND VPWR VPWR sky130_fd_sc_hd__fill_1
XFILLER_0_72_41 VGND VGND VPWR VPWR sky130_fd_sc_hd__decap_8
XFILLER_0_220_153 VPWR VGND VPWR VGND sky130_ef_sc_hd__decap_12
XFILLER_0_53_1253 VGND VGND VPWR VPWR sky130_fd_sc_hd__fill_1
XFILLER_0_220_197 VPWR VGND VPWR VGND sky130_ef_sc_hd__decap_12
XFILLER_0_119_647 VPWR VGND VPWR VGND sky130_ef_sc_hd__decap_12
XFILLER_0_107_809 VPWR VGND VPWR VGND sky130_ef_sc_hd__decap_12
XFILLER_0_134_617 VGND VGND VPWR VPWR sky130_fd_sc_hd__fill_1
XFILLER_0_17_645 VGND VGND VPWR VPWR sky130_fd_sc_hd__fill_1
XFILLER_0_124_1225 VGND VGND VPWR VPWR sky130_fd_sc_hd__fill_1
XFILLER_0_25_1311 VPWR VGND VPWR VGND sky130_ef_sc_hd__decap_12
XFILLER_0_60_1213 VPWR VGND VPWR VGND sky130_ef_sc_hd__decap_12
XFILLER_0_198_1337 VGND VGND VPWR VPWR sky130_fd_sc_hd__fill_1
XFILLER_0_95_1309 VGND VGND VPWR VPWR sky130_fd_sc_hd__fill_1
XTAP_2913 VGND VPWR sky130_fd_sc_hd__tapvpwrvgnd_1
XTAP_2902 VGND VPWR sky130_fd_sc_hd__tapvpwrvgnd_1
XFILLER_0_207_47 VGND VGND VPWR VPWR sky130_fd_sc_hd__decap_3
XFILLER_0_170_1201 VPWR VGND VPWR VGND sky130_ef_sc_hd__decap_12
XTAP_2946 VGND VPWR sky130_fd_sc_hd__tapvpwrvgnd_1
XFILLER_0_212_643 VGND VGND VPWR VPWR sky130_fd_sc_hd__fill_1
XTAP_2935 VGND VPWR sky130_fd_sc_hd__tapvpwrvgnd_1
XTAP_2924 VGND VPWR sky130_fd_sc_hd__tapvpwrvgnd_1
XFILLER_0_135_1343 VGND VGND VPWR VPWR sky130_fd_sc_hd__fill_1
XTAP_2957 VGND VPWR sky130_fd_sc_hd__tapvpwrvgnd_1
XFILLER_0_211_1231 VGND VGND VPWR VPWR sky130_fd_sc_hd__fill_1
XFILLER_0_223_57 VPWR VGND VPWR VGND sky130_ef_sc_hd__decap_12
XFILLER_0_32_1337 VGND VGND VPWR VPWR sky130_fd_sc_hd__fill_1
XFILLER_0_109_113 VPWR VGND VPWR VGND sky130_ef_sc_hd__decap_12
XFILLER_0_125_617 VPWR VGND VPWR VGND sky130_ef_sc_hd__decap_12
XANTENNA_input89_A psum_col1_in[30] VGND VGND VPWR VPWR sky130_fd_sc_hd__diode_2
XFILLER_0_105_385 VGND VGND VPWR VPWR sky130_fd_sc_hd__decap_6
XFILLER_0_103_1309 VGND VGND VPWR VPWR sky130_fd_sc_hd__fill_1
XFILLER_0_216_993 VPWR VGND VPWR VGND sky130_ef_sc_hd__decap_12
XFILLER_0_117_47 VGND VGND VPWR VPWR sky130_fd_sc_hd__decap_3
XFILLER_0_37_1237 VPWR VGND VPWR VGND sky130_ef_sc_hd__decap_12
XFILLER_0_76_1275 VGND VGND VPWR VPWR sky130_fd_sc_hd__decap_6
XFILLER_0_216_1197 VGND VGND VPWR VPWR sky130_fd_sc_hd__decap_6
XFILLER_0_212_1017 VPWR VGND VPWR VGND sky130_ef_sc_hd__decap_12
XFILLER_0_133_46 VGND VGND VPWR VPWR sky130_fd_sc_hd__decap_4
XFILLER_0_112_1173 VPWR VGND VPWR VGND sky130_ef_sc_hd__decap_12
XFILLER_0_116_617 VGND VGND VPWR VPWR sky130_fd_sc_hd__fill_1
XFILLER_0_6_837 VPWR VGND VPWR VGND sky130_ef_sc_hd__decap_12
XFILLER_0_186_1263 VPWR VGND VPWR VGND sky130_ef_sc_hd__decap_12
XFILLER_0_147_1225 VPWR VGND VPWR VGND sky130_ef_sc_hd__decap_12
XANTENNA_u_pe01_psum_in[13] net70 VGND VGND VPWR VPWR sky130_fd_sc_hd__diode_2
XFILLER_0_83_1213 VPWR VGND VPWR VGND sky130_ef_sc_hd__decap_12
XFILLER_0_223_1113 VGND VGND VPWR VPWR sky130_fd_sc_hd__decap_6
XFILLER_0_223_1157 VPWR VGND VPWR VGND sky130_ef_sc_hd__decap_12
XFILLER_0_112_867 VGND VGND VPWR VPWR sky130_fd_sc_hd__fill_1
XFILLER_0_1_553 VGND VGND VPWR VPWR sky130_fd_sc_hd__decap_6
XFILLER_0_83_1279 VPWR VGND VPWR VGND sky130_ef_sc_hd__decap_12
XFILLER_0_123_1291 VPWR VGND VPWR VGND sky130_ef_sc_hd__decap_12
XFILLER_0_1_597 VPWR VGND VPWR VGND sky130_ef_sc_hd__decap_12
XFILLER_0_6_77 VGND VGND VPWR VPWR sky130_fd_sc_hd__decap_6
XFILLER_0_193_1201 VPWR VGND VPWR VGND sky130_ef_sc_hd__decap_12
XFILLER_0_226_757 VPWR VGND VPWR VGND sky130_ef_sc_hd__decap_12
XFILLER_0_225_223 VGND VGND VPWR VPWR sky130_fd_sc_hd__fill_1
XFILLER_0_158_1343 VGND VGND VPWR VPWR sky130_fd_sc_hd__fill_1
XFILLER_0_20_1263 VPWR VGND VPWR VGND sky130_ef_sc_hd__decap_12
XFILLER_0_193_1267 VPWR VGND VPWR VGND sky130_ef_sc_hd__decap_12
XFILLER_0_213_429 VPWR VGND VPWR VGND sky130_ef_sc_hd__decap_12
XFILLER_0_94_1331 VGND VGND VPWR VPWR sky130_fd_sc_hd__decap_6
XFILLER_0_20_3 VPWR VGND VPWR VGND sky130_ef_sc_hd__decap_12
XTAP_2209 VGND VPWR sky130_fd_sc_hd__tapvpwrvgnd_1
XFILLER_0_221_473 VPWR VGND VPWR VGND sky130_ef_sc_hd__decap_12
XFILLER_0_90_1239 VPWR VGND VPWR VGND sky130_ef_sc_hd__decap_12
XPHY_37 VGND VGND VPWR VPWR sky130_fd_sc_hd__decap_3
XPHY_15 VGND VGND VPWR VPWR sky130_fd_sc_hd__decap_3
XPHY_26 VGND VGND VPWR VPWR sky130_fd_sc_hd__decap_3
XTAP_1508 VGND VPWR sky130_fd_sc_hd__tapvpwrvgnd_1
XTAP_1519 VGND VPWR sky130_fd_sc_hd__tapvpwrvgnd_1
XFILLER_0_190_41 VGND VGND VPWR VPWR sky130_fd_sc_hd__decap_8
XPHY_59 VGND VGND VPWR VPWR sky130_fd_sc_hd__decap_3
XPHY_48 VGND VGND VPWR VPWR sky130_fd_sc_hd__decap_3
XFILLER_0_130_1251 VPWR VGND VPWR VGND sky130_ef_sc_hd__decap_12
XFILLER_0_107_617 VPWR VGND VPWR VGND sky130_ef_sc_hd__decap_12
XFILLER_0_165_1303 VGND VGND VPWR VPWR sky130_fd_sc_hd__decap_6
XFILLER_0_130_1295 VPWR VGND VPWR VGND sky130_ef_sc_hd__decap_12
XFILLER_0_130_631 VPWR VGND VPWR VGND sky130_ef_sc_hd__decap_12
XFILLER_0_62_1319 VPWR VGND VPWR VGND sky130_ef_sc_hd__decap_12
XFILLER_0_114_193 VGND VGND VPWR VPWR sky130_fd_sc_hd__decap_3
XFILLER_0_102_1331 VGND VGND VPWR VPWR sky130_fd_sc_hd__decap_6
XANTENNA_input143_A w10[4] VGND VGND VPWR VPWR sky130_fd_sc_hd__diode_2
XFILLER_0_99_1253 VGND VGND VPWR VPWR sky130_fd_sc_hd__fill_1
XFILLER_0_216_245 VGND VGND VPWR VPWR sky130_fd_sc_hd__decap_6
XFILLER_0_216_289 VPWR VGND VPWR VGND sky130_ef_sc_hd__decap_12
XFILLER_0_172_1307 VPWR VGND VPWR VGND sky130_ef_sc_hd__decap_12
XTAP_2721 VGND VPWR sky130_fd_sc_hd__tapvpwrvgnd_1
XTAP_2710 VGND VPWR sky130_fd_sc_hd__tapvpwrvgnd_1
XFILLER_0_87_629 VPWR VGND VPWR VGND sky130_ef_sc_hd__decap_12
XTAP_2754 VGND VPWR sky130_fd_sc_hd__tapvpwrvgnd_1
XFILLER_0_213_1337 VGND VGND VPWR VPWR sky130_fd_sc_hd__decap_6
XTAP_2743 VGND VPWR sky130_fd_sc_hd__tapvpwrvgnd_1
XTAP_2732 VGND VPWR sky130_fd_sc_hd__tapvpwrvgnd_1
XTAP_2776 VGND VPWR sky130_fd_sc_hd__tapvpwrvgnd_1
XTAP_2765 VGND VPWR sky130_fd_sc_hd__tapvpwrvgnd_1
XTAP_2787 VGND VPWR sky130_fd_sc_hd__tapvpwrvgnd_1
XFILLER_0_36_1281 VGND VGND VPWR VPWR sky130_fd_sc_hd__fill_1
XTAP_2798 VGND VPWR sky130_fd_sc_hd__tapvpwrvgnd_1
XFILLER_0_103_27 VPWR VGND VPWR VGND sky130_ef_sc_hd__decap_12
XFILLER_0_113_609 VGND VGND VPWR VPWR sky130_fd_sc_hd__decap_6
XFILLER_0_88_29 VPWR VGND VPWR VGND sky130_ef_sc_hd__decap_12
XFILLER_0_107_1231 VGND VGND VPWR VPWR sky130_fd_sc_hd__fill_1
XFILLER_0_11_629 VPWR VGND VPWR VGND sky130_ef_sc_hd__decap_12
XFILLER_0_105_193 VPWR VGND VPWR VGND sky130_ef_sc_hd__decap_12
XFILLER_0_78_1337 VGND VGND VPWR VPWR sky130_fd_sc_hd__fill_1
XFILLER_0_223_727 VGND VGND VPWR VPWR sky130_fd_sc_hd__fill_1
XFILLER_0_218_1259 VGND VGND VPWR VPWR sky130_fd_sc_hd__fill_1
XFILLER_0_188_631 VPWR VGND VPWR VGND sky130_ef_sc_hd__decap_12
XFILLER_0_163_3 VPWR VGND VPWR VGND sky130_ef_sc_hd__decap_12
XFILLER_0_50_1201 VPWR VGND VPWR VGND sky130_ef_sc_hd__decap_12
XFILLER_0_114_1257 VGND VGND VPWR VPWR sky130_fd_sc_hd__decap_3
XFILLER_0_15_1343 VGND VGND VPWR VPWR sky130_fd_sc_hd__fill_1
XFILLER_0_149_1309 VGND VGND VPWR VPWR sky130_fd_sc_hd__fill_1
XFILLER_0_6_601 VPWR VGND VPWR VGND sky130_ef_sc_hd__decap_12
XFILLER_0_5_111 VGND VGND VPWR VPWR sky130_fd_sc_hd__fill_1
XFILLER_0_6_645 VPWR VGND VPWR VGND sky130_ef_sc_hd__decap_12
XFILLER_0_108_1017 VPWR VGND VPWR VGND sky130_ef_sc_hd__decap_12
XFILLER_0_68_3 VPWR VGND VPWR VGND sky130_ef_sc_hd__decap_12
XFILLER_0_1_361 VPWR VGND VPWR VGND sky130_ef_sc_hd__decap_12
XFILLER_0_214_749 VGND VGND VPWR VPWR sky130_fd_sc_hd__decap_6
XFILLER_0_213_237 VPWR VGND VPWR VGND sky130_ef_sc_hd__decap_12
XTAP_2006 VGND VPWR sky130_fd_sc_hd__tapvpwrvgnd_1
XFILLER_0_210_922 VGND VGND VPWR VPWR sky130_fd_sc_hd__fill_2
XTAP_2039 VGND VPWR sky130_fd_sc_hd__tapvpwrvgnd_1
XTAP_2017 VGND VPWR sky130_fd_sc_hd__tapvpwrvgnd_1
XTAP_1305 VGND VPWR sky130_fd_sc_hd__tapvpwrvgnd_1
XFILLER_0_69_629 VPWR VGND VPWR VGND sky130_ef_sc_hd__decap_12
XTAP_2028 VGND VPWR sky130_fd_sc_hd__tapvpwrvgnd_1
XFILLER_0_222_793 VPWR VGND VPWR VGND sky130_ef_sc_hd__decap_12
XFILLER_0_221_281 VPWR VGND VPWR VGND sky130_ef_sc_hd__decap_12
XFILLER_0_204_15 VPWR VGND VPWR VGND sky130_ef_sc_hd__decap_12
XTAP_1327 VGND VPWR sky130_fd_sc_hd__tapvpwrvgnd_1
XTAP_1316 VGND VPWR sky130_fd_sc_hd__tapvpwrvgnd_1
XTAP_1338 VGND VPWR sky130_fd_sc_hd__tapvpwrvgnd_1
XTAP_1349 VGND VPWR sky130_fd_sc_hd__tapvpwrvgnd_1
XFILLER_0_92_643 VPWR VGND VPWR VGND sky130_ef_sc_hd__decap_12
XFILLER_0_108_937 VPWR VGND VPWR VGND sky130_ef_sc_hd__decap_12
XFILLER_0_220_25 VGND VGND VPWR VPWR sky130_fd_sc_hd__decap_3
XFILLER_0_169_1291 VPWR VGND VPWR VGND sky130_ef_sc_hd__decap_12
XFILLER_0_107_447 VGND VGND VPWR VPWR sky130_fd_sc_hd__fill_1
XFILLER_0_27_1225 VPWR VGND VPWR VGND sky130_ef_sc_hd__decap_12
XFILLER_0_66_1263 VPWR VGND VPWR VGND sky130_ef_sc_hd__decap_12
XFILLER_0_176_1251 VPWR VGND VPWR VGND sky130_ef_sc_hd__decap_12
XFILLER_0_137_1213 VPWR VGND VPWR VGND sky130_ef_sc_hd__decap_12
XFILLER_0_176_1295 VPWR VGND VPWR VGND sky130_ef_sc_hd__decap_12
XFILLER_0_73_1201 VPWR VGND VPWR VGND sky130_ef_sc_hd__decap_12
XFILLER_0_213_1101 VPWR VGND VPWR VGND sky130_ef_sc_hd__decap_12
XFILLER_0_137_1279 VPWR VGND VPWR VGND sky130_ef_sc_hd__decap_12
XFILLER_0_38_1343 VGND VGND VPWR VPWR sky130_fd_sc_hd__fill_1
XFILLER_0_217_1281 VGND VGND VPWR VPWR sky130_fd_sc_hd__decap_6
XFILLER_0_213_1145 VPWR VGND VPWR VGND sky130_ef_sc_hd__decap_12
XTAP_2562 VGND VPWR sky130_fd_sc_hd__tapvpwrvgnd_1
XTAP_2551 VGND VPWR sky130_fd_sc_hd__tapvpwrvgnd_1
XTAP_2540 VGND VPWR sky130_fd_sc_hd__tapvpwrvgnd_1
XFILLER_0_73_1267 VPWR VGND VPWR VGND sky130_ef_sc_hd__decap_12
XTAP_2584 VGND VPWR sky130_fd_sc_hd__tapvpwrvgnd_1
XFILLER_0_185_645 VGND VGND VPWR VPWR sky130_fd_sc_hd__fill_1
XTAP_2573 VGND VPWR sky130_fd_sc_hd__tapvpwrvgnd_1
XTAP_2595 VGND VPWR sky130_fd_sc_hd__tapvpwrvgnd_1
XTAP_1861 VGND VPWR sky130_fd_sc_hd__tapvpwrvgnd_1
XTAP_1850 VGND VPWR sky130_fd_sc_hd__tapvpwrvgnd_1
XFILLER_0_213_1189 VPWR VGND VPWR VGND sky130_ef_sc_hd__decap_12
XTAP_1883 VGND VPWR sky130_fd_sc_hd__tapvpwrvgnd_1
XTAP_1872 VGND VPWR sky130_fd_sc_hd__tapvpwrvgnd_1
XTAP_1894 VGND VPWR sky130_fd_sc_hd__tapvpwrvgnd_1
XFILLER_0_148_1331 VGND VGND VPWR VPWR sky130_fd_sc_hd__decap_6
XFILLER_0_10_1251 VPWR VGND VPWR VGND sky130_ef_sc_hd__decap_12
XFILLER_0_99_39 VGND VGND VPWR VPWR sky130_fd_sc_hd__decap_8
XFILLER_0_183_1255 VPWR VGND VPWR VGND sky130_ef_sc_hd__decap_12
XFILLER_0_109_1337 VGND VGND VPWR VPWR sky130_fd_sc_hd__decap_6
XFILLER_0_3_615 VGND VGND VPWR VPWR sky130_fd_sc_hd__fill_1
XFILLER_0_113_417 VPWR VGND VPWR VGND sky130_ef_sc_hd__decap_12
XFILLER_0_224_1241 VPWR VGND VPWR VGND sky130_ef_sc_hd__decap_12
XFILLER_0_144_1239 VPWR VGND VPWR VGND sky130_ef_sc_hd__decap_12
XFILLER_0_10_1295 VPWR VGND VPWR VGND sky130_ef_sc_hd__decap_12
XFILLER_0_45_1303 VGND VGND VPWR VPWR sky130_fd_sc_hd__decap_6
XFILLER_0_220_1105 VPWR VGND VPWR VGND sky130_ef_sc_hd__decap_12
XFILLER_0_210_91 VPWR VGND VPWR VGND sky130_ef_sc_hd__decap_12
XFILLER_0_80_1227 VPWR VGND VPWR VGND sky130_ef_sc_hd__decap_12
XFILLER_0_224_1285 VPWR VGND VPWR VGND sky130_ef_sc_hd__decap_12
XFILLER_0_220_1149 VPWR VGND VPWR VGND sky130_ef_sc_hd__decap_12
XFILLER_0_120_1283 VPWR VGND VPWR VGND sky130_ef_sc_hd__decap_12
XFILLER_0_3_23 VPWR VGND VPWR VGND sky130_ef_sc_hd__decap_12
XFILLER_0_155_1335 VGND VGND VPWR VPWR sky130_fd_sc_hd__fill_1
XFILLER_0_116_1319 VPWR VGND VPWR VGND sky130_ef_sc_hd__decap_12
XFILLER_0_91_1323 VPWR VGND VPWR VGND sky130_ef_sc_hd__decap_12
XFILLER_0_114_1021 VPWR VGND VPWR VGND sky130_ef_sc_hd__decap_12
XFILLER_0_52_1307 VPWR VGND VPWR VGND sky130_ef_sc_hd__decap_12
XFILLER_0_171_10 VPWR VGND VPWR VGND sky130_ef_sc_hd__decap_12
XFILLER_0_80_41 VGND VGND VPWR VPWR sky130_fd_sc_hd__decap_8
XFILLER_0_4_1105 VPWR VGND VPWR VGND sky130_ef_sc_hd__decap_12
XFILLER_0_8_1263 VPWR VGND VPWR VGND sky130_ef_sc_hd__decap_12
XPHY_1009 VGND VGND VPWR VPWR sky130_fd_sc_hd__decap_3
XFILLER_0_114_1065 VPWR VGND VPWR VGND sky130_ef_sc_hd__decap_12
XFILLER_0_74_643 VPWR VGND VPWR VGND sky130_ef_sc_hd__decap_12
XFILLER_0_4_1149 VPWR VGND VPWR VGND sky130_ef_sc_hd__decap_12
XFILLER_0_7_921 VGND VGND VPWR VPWR sky130_fd_sc_hd__decap_3
XFILLER_0_104_81 VGND VGND VPWR VPWR sky130_fd_sc_hd__decap_3
XFILLER_0_7_965 VPWR VGND VPWR VGND sky130_ef_sc_hd__decap_12
XFILLER_0_6_475 VGND VGND VPWR VPWR sky130_fd_sc_hd__fill_1
XFILLER_0_104_417 VGND VGND VPWR VPWR sky130_fd_sc_hd__decap_3
XFILLER_0_162_1339 VGND VGND VPWR VPWR sky130_fd_sc_hd__decap_4
XFILLER_0_113_951 VGND VGND VPWR VPWR sky130_fd_sc_hd__fill_1
XFILLER_0_203_1303 VGND VGND VPWR VPWR sky130_fd_sc_hd__decap_6
XFILLER_0_218_307 VGND VGND VPWR VPWR sky130_fd_sc_hd__fill_1
XFILLER_0_2_681 VPWR VGND VPWR VGND sky130_ef_sc_hd__decap_12
XFILLER_0_96_1201 VPWR VGND VPWR VGND sky130_ef_sc_hd__decap_12
XFILLER_0_214_513 VPWR VGND VPWR VGND sky130_ef_sc_hd__decap_12
XFILLER_0_226_373 VGND VGND VPWR VPWR sky130_fd_sc_hd__fill_2
XFILLER_0_214_557 VPWR VGND VPWR VGND sky130_ef_sc_hd__decap_12
XFILLER_0_215_69 VPWR VGND VPWR VGND sky130_ef_sc_hd__decap_12
XFILLER_0_210_741 VPWR VGND VPWR VGND sky130_ef_sc_hd__decap_12
XPHY_900 VGND VGND VPWR VPWR sky130_fd_sc_hd__decap_3
XFILLER_0_167_645 VGND VGND VPWR VPWR sky130_fd_sc_hd__fill_1
XPHY_911 VGND VGND VPWR VPWR sky130_fd_sc_hd__decap_3
XANTENNA_input106_A w00[14] VGND VGND VPWR VPWR sky130_fd_sc_hd__diode_2
XFILLER_0_210_1329 VPWR VGND VPWR VGND sky130_ef_sc_hd__decap_12
XFILLER_0_210_785 VPWR VGND VPWR VGND sky130_ef_sc_hd__decap_12
XPHY_922 VGND VGND VPWR VPWR sky130_fd_sc_hd__decap_3
XFILLER_0_108_701 VPWR VGND VPWR VGND sky130_ef_sc_hd__decap_12
XPHY_944 VGND VGND VPWR VPWR sky130_fd_sc_hd__decap_3
XPHY_933 VGND VGND VPWR VPWR sky130_fd_sc_hd__decap_3
XPHY_988 VGND VGND VPWR VPWR sky130_fd_sc_hd__decap_3
XPHY_977 VGND VGND VPWR VPWR sky130_fd_sc_hd__decap_3
XPHY_966 VGND VGND VPWR VPWR sky130_fd_sc_hd__decap_3
XPHY_955 VGND VGND VPWR VPWR sky130_fd_sc_hd__decap_3
XPHY_999 VGND VGND VPWR VPWR sky130_fd_sc_hd__decap_3
XFILLER_0_208_1225 VGND VGND VPWR VPWR sky130_fd_sc_hd__fill_1
XFILLER_0_29_1309 VGND VGND VPWR VPWR sky130_fd_sc_hd__fill_1
XANTENNA_input71_A psum_col1_in[14] VGND VGND VPWR VPWR sky130_fd_sc_hd__diode_2
XFILLER_0_104_1201 VGND VGND VPWR VPWR sky130_fd_sc_hd__decap_3
XFILLER_0_104_1245 VPWR VGND VPWR VGND sky130_ef_sc_hd__decap_12
XFILLER_0_104_1289 VPWR VGND VPWR VGND sky130_ef_sc_hd__decap_12
XFILLER_0_109_15 VPWR VGND VPWR VGND sky130_ef_sc_hd__decap_12
XFILLER_0_217_373 VPWR VGND VPWR VGND sky130_ef_sc_hd__decap_12
XFILLER_0_219_1343 VGND VGND VPWR VPWR sky130_fd_sc_hd__fill_1
XFILLER_0_125_47 VGND VGND VPWR VPWR sky130_fd_sc_hd__decap_3
XTAP_2370 VGND VPWR sky130_fd_sc_hd__tapvpwrvgnd_1
XTAP_2392 VGND VPWR sky130_fd_sc_hd__tapvpwrvgnd_1
XTAP_2381 VGND VPWR sky130_fd_sc_hd__tapvpwrvgnd_1
XFILLER_0_56_643 VPWR VGND VPWR VGND sky130_ef_sc_hd__decap_12
XTAP_1680 VGND VPWR sky130_fd_sc_hd__tapvpwrvgnd_1
XTAP_1691 VGND VPWR sky130_fd_sc_hd__tapvpwrvgnd_1
XANTENNA_u_pe01_weight_in[0] net117 VGND VGND VPWR VPWR sky130_fd_sc_hd__diode_2
XFILLER_0_109_1101 VPWR VGND VPWR VGND sky130_ef_sc_hd__decap_12
XFILLER_0_109_1145 VPWR VGND VPWR VGND sky130_ef_sc_hd__decap_12
XFILLER_0_113_225 VPWR VGND VPWR VGND sky130_ef_sc_hd__decap_12
XFILLER_0_105_1009 VPWR VGND VPWR VGND sky130_ef_sc_hd__decap_12
XFILLER_0_4_979 VGND VGND VPWR VPWR sky130_fd_sc_hd__fill_1
XFILLER_0_49_1291 VPWR VGND VPWR VGND sky130_ef_sc_hd__decap_12
XFILLER_0_109_1189 VPWR VGND VPWR VGND sky130_ef_sc_hd__decap_12
XFILLER_0_224_1093 VPWR VGND VPWR VGND sky130_ef_sc_hd__decap_12
XANTENNA_u_pe00_act_in[5] net12 VGND VGND VPWR VPWR sky130_fd_sc_hd__diode_2
XFILLER_0_224_811 VGND VGND VPWR VPWR sky130_fd_sc_hd__fill_1
XFILLER_0_211_505 VPWR VGND VPWR VGND sky130_ef_sc_hd__decap_12
XFILLER_0_17_1213 VPWR VGND VPWR VGND sky130_ef_sc_hd__decap_12
XFILLER_0_56_1251 VPWR VGND VPWR VGND sky130_ef_sc_hd__decap_12
XFILLER_0_149_645 VGND VGND VPWR VPWR sky130_fd_sc_hd__fill_1
XPHY_207 VGND VGND VPWR VPWR sky130_fd_sc_hd__decap_3
XFILLER_0_56_1295 VPWR VGND VPWR VGND sky130_ef_sc_hd__decap_12
XPHY_229 VGND VGND VPWR VPWR sky130_fd_sc_hd__decap_3
XFILLER_0_17_1279 VPWR VGND VPWR VGND sky130_ef_sc_hd__decap_12
XPHY_218 VGND VGND VPWR VPWR sky130_fd_sc_hd__decap_3
XFILLER_0_201_27 VPWR VGND VPWR VGND sky130_ef_sc_hd__decap_12
XFILLER_0_127_1201 VPWR VGND VPWR VGND sky130_ef_sc_hd__decap_12
XFILLER_0_166_1283 VPWR VGND VPWR VGND sky130_ef_sc_hd__decap_12
XFILLER_0_104_225 VPWR VGND VPWR VGND sky130_ef_sc_hd__decap_12
XFILLER_0_127_1267 VPWR VGND VPWR VGND sky130_ef_sc_hd__decap_12
XFILLER_0_28_1331 VGND VGND VPWR VPWR sky130_fd_sc_hd__decap_6
XFILLER_0_207_1291 VPWR VGND VPWR VGND sky130_ef_sc_hd__decap_12
XFILLER_0_63_1255 VPWR VGND VPWR VGND sky130_ef_sc_hd__decap_12
XFILLER_0_98_1307 VPWR VGND VPWR VGND sky130_ef_sc_hd__decap_12
XFILLER_0_24_1239 VPWR VGND VPWR VGND sky130_ef_sc_hd__decap_12
XFILLER_0_215_833 VGND VGND VPWR VPWR sky130_fd_sc_hd__decap_6
XFILLER_0_214_321 VPWR VGND VPWR VGND sky130_ef_sc_hd__decap_12
XFILLER_0_215_877 VPWR VGND VPWR VGND sky130_ef_sc_hd__decap_12
XFILLER_0_226_57 VGND VGND VPWR VPWR sky130_fd_sc_hd__decap_8
XFILLER_0_214_365 VPWR VGND VPWR VGND sky130_ef_sc_hd__decap_12
XANTENNA_u_pe01_rst_n net98 VGND VGND VPWR VPWR sky130_fd_sc_hd__diode_2
XFILLER_0_134_1227 VPWR VGND VPWR VGND sky130_ef_sc_hd__decap_12
XFILLER_0_35_1335 VGND VGND VPWR VPWR sky130_fd_sc_hd__fill_1
XFILLER_0_214_1273 VPWR VGND VPWR VGND sky130_ef_sc_hd__decap_12
XPHY_763 VGND VGND VPWR VPWR sky130_fd_sc_hd__decap_3
XPHY_730 VGND VGND VPWR VPWR sky130_fd_sc_hd__decap_3
XFILLER_0_38_643 VPWR VGND VPWR VGND sky130_ef_sc_hd__decap_12
XPHY_741 VGND VGND VPWR VPWR sky130_fd_sc_hd__decap_3
XPHY_752 VGND VGND VPWR VPWR sky130_fd_sc_hd__decap_3
XANTENNA_u_pe00_psum_in[30] net57 VGND VGND VPWR VPWR sky130_fd_sc_hd__diode_2
XPHY_774 VGND VGND VPWR VPWR sky130_fd_sc_hd__decap_3
XPHY_796 VGND VGND VPWR VPWR sky130_fd_sc_hd__decap_3
XPHY_785 VGND VGND VPWR VPWR sky130_fd_sc_hd__decap_3
XFILLER_0_108_531 VGND VGND VPWR VPWR sky130_fd_sc_hd__fill_1
XFILLER_0_4_209 VPWR VGND VPWR VGND sky130_ef_sc_hd__decap_12
XFILLER_0_111_27 VPWR VGND VPWR VGND sky130_ef_sc_hd__decap_12
XFILLER_0_145_1323 VPWR VGND VPWR VGND sky130_ef_sc_hd__decap_12
XFILLER_0_180_1225 VGND VGND VPWR VPWR sky130_fd_sc_hd__fill_1
XFILLER_0_111_729 VPWR VGND VPWR VGND sky130_ef_sc_hd__decap_12
XFILLER_0_81_1311 VPWR VGND VPWR VGND sky130_ef_sc_hd__decap_12
XFILLER_0_106_1329 VPWR VGND VPWR VGND sky130_ef_sc_hd__decap_12
XFILLER_0_104_781 VGND VGND VPWR VPWR sky130_fd_sc_hd__decap_3
XFILLER_0_96_29 VPWR VGND VPWR VGND sky130_ef_sc_hd__decap_12
XFILLER_0_221_1233 VPWR VGND VPWR VGND sky130_ef_sc_hd__decap_12
XFILLER_0_42_1339 VGND VGND VPWR VPWR sky130_fd_sc_hd__decap_4
XFILLER_0_218_693 VGND VGND VPWR VPWR sky130_fd_sc_hd__decap_6
XFILLER_0_217_181 VPWR VGND VPWR VGND sky130_ef_sc_hd__decap_12
XFILLER_0_17_9 VGND VGND VPWR VPWR sky130_fd_sc_hd__fill_2
XFILLER_0_220_357 VGND VGND VPWR VPWR sky130_fd_sc_hd__decap_6
XFILLER_0_0_57 VPWR VGND VPWR VGND sky130_ef_sc_hd__decap_12
XFILLER_0_0_35 VPWR VGND VPWR VGND sky130_ef_sc_hd__decap_12
XFILLER_0_5_1233 VPWR VGND VPWR VGND sky130_ef_sc_hd__decap_12
XFILLER_0_201_593 VPWR VGND VPWR VGND sky130_ef_sc_hd__decap_12
XFILLER_0_111_1057 VGND VGND VPWR VPWR sky130_fd_sc_hd__decap_6
XFILLER_0_1_1119 VGND VGND VPWR VPWR sky130_fd_sc_hd__fill_1
XFILLER_0_161_629 VPWR VGND VPWR VGND sky130_ef_sc_hd__decap_12
XFILLER_0_114_501 VGND VGND VPWR VPWR sky130_fd_sc_hd__decap_3
XFILLER_0_114_545 VPWR VGND VPWR VGND sky130_ef_sc_hd__decap_12
XFILLER_0_226_1177 VGND VGND VPWR VPWR sky130_fd_sc_hd__decap_6
XFILLER_0_114_589 VPWR VGND VPWR VGND sky130_ef_sc_hd__decap_12
XFILLER_0_200_1339 VGND VGND VPWR VPWR sky130_fd_sc_hd__decap_4
XFILLER_0_50_3 VPWR VGND VPWR VGND sky130_ef_sc_hd__decap_12
XFILLER_0_157_1249 VGND VGND VPWR VPWR sky130_fd_sc_hd__decap_4
XFILLER_0_93_1237 VPWR VGND VPWR VGND sky130_ef_sc_hd__decap_12
XFILLER_0_212_825 VPWR VGND VPWR VGND sky130_ef_sc_hd__decap_12
XFILLER_0_212_869 VPWR VGND VPWR VGND sky130_ef_sc_hd__decap_12
XFILLER_0_211_335 VGND VGND VPWR VPWR sky130_fd_sc_hd__fill_1
XFILLER_0_212_15 VPWR VGND VPWR VGND sky130_ef_sc_hd__decap_12
XFILLER_0_109_317 VPWR VGND VPWR VGND sky130_ef_sc_hd__decap_12
XFILLER_0_209_1331 VGND VGND VPWR VPWR sky130_fd_sc_hd__fill_2
XFILLER_0_50_605 VPWR VGND VPWR VGND sky130_ef_sc_hd__decap_12
XFILLER_0_140_1275 VGND VGND VPWR VPWR sky130_fd_sc_hd__decap_6
XFILLER_0_101_1237 VPWR VGND VPWR VGND sky130_ef_sc_hd__decap_12
XANTENNA_input34_A psum_col0_in[0] VGND VGND VPWR VPWR sky130_fd_sc_hd__diode_2
XFILLER_0_215_641 VPWR VGND VPWR VGND sky130_ef_sc_hd__decap_12
XFILLER_0_215_685 VPWR VGND VPWR VGND sky130_ef_sc_hd__decap_12
XFILLER_0_106_27 VGND VGND VPWR VPWR sky130_fd_sc_hd__fill_1
XFILLER_0_214_195 VGND VGND VPWR VPWR sky130_fd_sc_hd__fill_1
XFILLER_0_15_47 VGND VGND VPWR VPWR sky130_fd_sc_hd__decap_3
XPHY_560 VGND VGND VPWR VPWR sky130_fd_sc_hd__decap_3
XPHY_571 VGND VGND VPWR VPWR sky130_fd_sc_hd__decap_3
XFILLER_0_31_13 VPWR VGND VPWR VGND sky130_ef_sc_hd__decap_12
XPHY_593 VGND VGND VPWR VPWR sky130_fd_sc_hd__decap_3
XFILLER_0_143_629 VPWR VGND VPWR VGND sky130_ef_sc_hd__decap_12
XPHY_582 VGND VGND VPWR VPWR sky130_fd_sc_hd__decap_3
XFILLER_0_5_529 VPWR VGND VPWR VGND sky130_ef_sc_hd__decap_12
XPHY_1170 VGND VGND VPWR VPWR sky130_fd_sc_hd__decap_3
XPHY_1181 VGND VGND VPWR VPWR sky130_fd_sc_hd__decap_3
XPHY_1192 VGND VGND VPWR VPWR sky130_fd_sc_hd__decap_3
XFILLER_0_109_895 VGND VGND VPWR VPWR sky130_fd_sc_hd__fill_1
XFILLER_0_41_605 VPWR VGND VPWR VGND sky130_ef_sc_hd__decap_12
XFILLER_0_111_559 VGND VGND VPWR VPWR sky130_fd_sc_hd__fill_1
XFILLER_0_0_223 VGND VGND VPWR VPWR sky130_fd_sc_hd__fill_1
XFILLER_0_46_1283 VPWR VGND VPWR VGND sky130_ef_sc_hd__decap_12
XFILLER_0_221_1063 VGND VGND VPWR VPWR sky130_fd_sc_hd__fill_1
XFILLER_0_193_3 VPWR VGND VPWR VGND sky130_ef_sc_hd__decap_12
XFILLER_0_225_405 VPWR VGND VPWR VGND sky130_ef_sc_hd__decap_12
XFILLER_0_147_34 VPWR VGND VPWR VGND sky130_ef_sc_hd__decap_12
XFILLER_0_225_449 VPWR VGND VPWR VGND sky130_ef_sc_hd__decap_12
XFILLER_0_220_121 VPWR VGND VPWR VGND sky130_ef_sc_hd__decap_12
XFILLER_0_117_1255 VPWR VGND VPWR VGND sky130_ef_sc_hd__decap_12
XFILLER_0_7_1317 VPWR VGND VPWR VGND sky130_ef_sc_hd__decap_12
XFILLER_0_220_165 VPWR VGND VPWR VGND sky130_ef_sc_hd__decap_12
XFILLER_0_113_1119 VGND VGND VPWR VPWR sky130_fd_sc_hd__fill_1
XFILLER_0_92_1281 VGND VGND VPWR VPWR sky130_fd_sc_hd__fill_1
XFILLER_0_14_1227 VPWR VGND VPWR VGND sky130_ef_sc_hd__decap_12
XFILLER_0_5_1063 VGND VGND VPWR VPWR sky130_fd_sc_hd__fill_1
XFILLER_0_88_1339 VGND VGND VPWR VPWR sky130_fd_sc_hd__decap_4
XFILLER_0_106_309 VPWR VGND VPWR VGND sky130_ef_sc_hd__decap_12
XFILLER_0_32_605 VPWR VGND VPWR VGND sky130_ef_sc_hd__decap_12
XFILLER_0_188_41 VGND VGND VPWR VPWR sky130_fd_sc_hd__decap_8
XFILLER_0_163_1253 VGND VGND VPWR VPWR sky130_fd_sc_hd__fill_1
XFILLER_0_25_1323 VPWR VGND VPWR VGND sky130_ef_sc_hd__decap_12
XFILLER_0_60_1225 VGND VGND VPWR VPWR sky130_fd_sc_hd__fill_1
XFILLER_0_204_1283 VPWR VGND VPWR VGND sky130_ef_sc_hd__decap_12
XFILLER_0_110_581 VGND VGND VPWR VPWR sky130_fd_sc_hd__decap_6
XFILLER_0_207_15 VPWR VGND VPWR VGND sky130_ef_sc_hd__decap_12
XFILLER_0_99_605 VPWR VGND VPWR VGND sky130_ef_sc_hd__decap_12
XTAP_2903 VGND VPWR sky130_fd_sc_hd__tapvpwrvgnd_1
XFILLER_0_135_1311 VPWR VGND VPWR VGND sky130_ef_sc_hd__decap_12
XFILLER_0_100_1281 VGND VGND VPWR VPWR sky130_fd_sc_hd__fill_1
XTAP_2914 VGND VPWR sky130_fd_sc_hd__tapvpwrvgnd_1
XTAP_2936 VGND VPWR sky130_fd_sc_hd__tapvpwrvgnd_1
XTAP_2925 VGND VPWR sky130_fd_sc_hd__tapvpwrvgnd_1
XFILLER_0_170_1213 VPWR VGND VPWR VGND sky130_ef_sc_hd__decap_12
XTAP_2958 VGND VPWR sky130_fd_sc_hd__tapvpwrvgnd_1
XTAP_2947 VGND VPWR sky130_fd_sc_hd__tapvpwrvgnd_1
XFILLER_0_212_699 VGND VGND VPWR VPWR sky130_fd_sc_hd__fill_1
XFILLER_0_223_69 VPWR VGND VPWR VGND sky130_ef_sc_hd__decap_12
XFILLER_0_109_125 VPWR VGND VPWR VGND sky130_ef_sc_hd__decap_12
XFILLER_0_211_1287 VGND VGND VPWR VPWR sky130_fd_sc_hd__fill_1
XFILLER_0_125_629 VPWR VGND VPWR VGND sky130_ef_sc_hd__decap_12
XFILLER_0_109_169 VPWR VGND VPWR VGND sky130_ef_sc_hd__decap_12
XFILLER_0_23_605 VPWR VGND VPWR VGND sky130_ef_sc_hd__decap_12
XFILLER_0_90_593 VPWR VGND VPWR VGND sky130_ef_sc_hd__decap_12
XFILLER_0_142_1337 VGND VGND VPWR VPWR sky130_fd_sc_hd__fill_1
XFILLER_0_223_909 VPWR VGND VPWR VGND sky130_ef_sc_hd__decap_12
XFILLER_0_216_961 VPWR VGND VPWR VGND sky130_ef_sc_hd__decap_12
XFILLER_0_117_15 VPWR VGND VPWR VGND sky130_ef_sc_hd__decap_12
XFILLER_0_222_419 VGND VGND VPWR VPWR sky130_fd_sc_hd__fill_1
XFILLER_0_37_1249 VGND VGND VPWR VPWR sky130_fd_sc_hd__decap_4
XFILLER_0_212_1029 VGND VGND VPWR VPWR sky130_fd_sc_hd__decap_6
XFILLER_0_112_1141 VGND VGND VPWR VPWR sky130_fd_sc_hd__decap_6
XFILLER_0_2_1203 VGND VGND VPWR VPWR sky130_fd_sc_hd__fill_1
XFILLER_0_112_1185 VPWR VGND VPWR VGND sky130_ef_sc_hd__decap_12
XFILLER_0_6_805 VGND VGND VPWR VPWR sky130_fd_sc_hd__decap_6
XFILLER_0_186_1275 VGND VGND VPWR VPWR sky130_fd_sc_hd__decap_6
XFILLER_0_5_337 VPWR VGND VPWR VGND sky130_ef_sc_hd__decap_12
XFILLER_0_6_849 VPWR VGND VPWR VGND sky130_ef_sc_hd__decap_12
XFILLER_0_14_605 VPWR VGND VPWR VGND sky130_ef_sc_hd__decap_12
XPHY_390 VGND VGND VPWR VPWR sky130_fd_sc_hd__decap_3
XANTENNA_u_pe01_psum_in[12] net69 VGND VGND VPWR VPWR sky130_fd_sc_hd__diode_2
XFILLER_0_147_1237 VPWR VGND VPWR VGND sky130_ef_sc_hd__decap_12
XFILLER_0_81_593 VPWR VGND VPWR VGND sky130_ef_sc_hd__decap_12
XFILLER_0_83_1225 VPWR VGND VPWR VGND sky130_ef_sc_hd__decap_12
XFILLER_0_112_813 VPWR VGND VPWR VGND sky130_ef_sc_hd__decap_12
XFILLER_0_223_1169 VGND VGND VPWR VPWR sky130_fd_sc_hd__decap_6
XFILLER_0_226_736 VPWR VGND VPWR VGND sky130_ef_sc_hd__decap_12
XFILLER_0_193_1213 VPWR VGND VPWR VGND sky130_ef_sc_hd__decap_12
XFILLER_0_226_769 VGND VGND VPWR VPWR sky130_fd_sc_hd__fill_2
XFILLER_0_193_1279 VPWR VGND VPWR VGND sky130_ef_sc_hd__decap_12
XFILLER_0_225_279 VGND VGND VPWR VPWR sky130_fd_sc_hd__fill_1
XFILLER_0_94_1343 VGND VGND VPWR VPWR sky130_fd_sc_hd__fill_1
XFILLER_0_20_1275 VGND VGND VPWR VPWR sky130_fd_sc_hd__decap_6
XFILLER_0_221_441 VGND VGND VPWR VPWR sky130_fd_sc_hd__decap_6
XFILLER_0_96_619 VPWR VGND VPWR VGND sky130_ef_sc_hd__decap_12
XFILLER_0_13_3 VPWR VGND VPWR VGND sky130_ef_sc_hd__decap_12
XTAP_1509 VGND VPWR sky130_fd_sc_hd__tapvpwrvgnd_1
XPHY_16 VGND VGND VPWR VPWR sky130_fd_sc_hd__decap_3
XPHY_27 VGND VGND VPWR VPWR sky130_fd_sc_hd__decap_3
XPHY_38 VGND VGND VPWR VPWR sky130_fd_sc_hd__decap_3
XFILLER_0_107_81 VPWR VGND VPWR VGND sky130_ef_sc_hd__decap_12
XFILLER_0_221_485 VPWR VGND VPWR VGND sky130_ef_sc_hd__decap_12
XPHY_49 VGND VGND VPWR VPWR sky130_fd_sc_hd__decap_3
XFILLER_0_130_1263 VPWR VGND VPWR VGND sky130_ef_sc_hd__decap_12
XFILLER_0_107_629 VPWR VGND VPWR VGND sky130_ef_sc_hd__decap_12
XFILLER_0_72_593 VPWR VGND VPWR VGND sky130_ef_sc_hd__decap_12
XFILLER_0_106_139 VGND VGND VPWR VPWR sky130_fd_sc_hd__fill_1
XFILLER_0_130_643 VPWR VGND VPWR VGND sky130_ef_sc_hd__decap_12
XFILLER_0_20_619 VPWR VGND VPWR VGND sky130_ef_sc_hd__decap_12
XFILLER_0_102_1343 VGND VGND VPWR VPWR sky130_fd_sc_hd__fill_1
XANTENNA_input136_A w10[12] VGND VGND VPWR VPWR sky130_fd_sc_hd__diode_2
XFILLER_0_172_1319 VPWR VGND VPWR VGND sky130_ef_sc_hd__decap_12
XTAP_2700 VGND VPWR sky130_fd_sc_hd__tapvpwrvgnd_1
XFILLER_0_213_953 VPWR VGND VPWR VGND sky130_ef_sc_hd__decap_12
XTAP_2711 VGND VPWR sky130_fd_sc_hd__tapvpwrvgnd_1
XTAP_2755 VGND VPWR sky130_fd_sc_hd__tapvpwrvgnd_1
XTAP_2722 VGND VPWR sky130_fd_sc_hd__tapvpwrvgnd_1
XTAP_2744 VGND VPWR sky130_fd_sc_hd__tapvpwrvgnd_1
XTAP_2733 VGND VPWR sky130_fd_sc_hd__tapvpwrvgnd_1
XTAP_2777 VGND VPWR sky130_fd_sc_hd__tapvpwrvgnd_1
XTAP_2766 VGND VPWR sky130_fd_sc_hd__tapvpwrvgnd_1
XTAP_2788 VGND VPWR sky130_fd_sc_hd__tapvpwrvgnd_1
XFILLER_0_95_641 VGND VGND VPWR VPWR sky130_fd_sc_hd__decap_4
XTAP_2799 VGND VPWR sky130_fd_sc_hd__tapvpwrvgnd_1
XFILLER_0_12_15 VPWR VGND VPWR VGND sky130_ef_sc_hd__decap_12
XFILLER_0_103_39 VGND VGND VPWR VPWR sky130_fd_sc_hd__decap_8
XFILLER_0_63_593 VPWR VGND VPWR VGND sky130_ef_sc_hd__decap_12
XFILLER_0_2_307 VGND VGND VPWR VPWR sky130_fd_sc_hd__fill_1
XFILLER_0_105_161 VGND VGND VPWR VPWR sky130_fd_sc_hd__decap_6
XFILLER_0_112_109 VPWR VGND VPWR VGND sky130_ef_sc_hd__decap_12
XFILLER_0_146_1281 VGND VGND VPWR VPWR sky130_fd_sc_hd__fill_1
XFILLER_0_220_1309 VGND VGND VPWR VPWR sky130_fd_sc_hd__decap_6
XFILLER_0_107_1287 VGND VGND VPWR VPWR sky130_fd_sc_hd__fill_1
XFILLER_0_43_1253 VGND VGND VPWR VPWR sky130_fd_sc_hd__fill_1
XFILLER_0_218_1205 VPWR VGND VPWR VGND sky130_ef_sc_hd__decap_12
XFILLER_0_78_619 VPWR VGND VPWR VGND sky130_ef_sc_hd__decap_12
XFILLER_0_188_643 VPWR VGND VPWR VGND sky130_ef_sc_hd__decap_12
XFILLER_0_156_3 VPWR VGND VPWR VGND sky130_ef_sc_hd__decap_12
XFILLER_0_4_1309 VGND VGND VPWR VPWR sky130_fd_sc_hd__decap_6
XFILLER_0_15_1311 VPWR VGND VPWR VGND sky130_ef_sc_hd__decap_12
XFILLER_0_50_1213 VPWR VGND VPWR VGND sky130_ef_sc_hd__decap_12
XFILLER_0_188_1337 VGND VGND VPWR VPWR sky130_fd_sc_hd__fill_1
XFILLER_0_6_613 VPWR VGND VPWR VGND sky130_ef_sc_hd__decap_12
XFILLER_0_85_1309 VGND VGND VPWR VPWR sky130_fd_sc_hd__fill_1
XFILLER_0_6_657 VPWR VGND VPWR VGND sky130_ef_sc_hd__decap_12
XFILLER_0_108_1029 VGND VGND VPWR VPWR sky130_fd_sc_hd__decap_6
XFILLER_0_5_167 VGND VGND VPWR VPWR sky130_fd_sc_hd__fill_1
XFILLER_0_54_593 VPWR VGND VPWR VGND sky130_ef_sc_hd__decap_12
XFILLER_0_160_1201 VPWR VGND VPWR VGND sky130_ef_sc_hd__decap_12
XFILLER_0_112_643 VGND VGND VPWR VPWR sky130_fd_sc_hd__fill_1
XFILLER_0_78_41 VGND VGND VPWR VPWR sky130_fd_sc_hd__decap_8
XFILLER_0_1_373 VPWR VGND VPWR VGND sky130_ef_sc_hd__decap_12
XFILLER_0_201_1253 VGND VGND VPWR VPWR sky130_fd_sc_hd__fill_1
XFILLER_0_22_1337 VGND VGND VPWR VPWR sky130_fd_sc_hd__fill_1
XFILLER_0_213_205 VPWR VGND VPWR VGND sky130_ef_sc_hd__decap_12
XFILLER_0_213_249 VPWR VGND VPWR VGND sky130_ef_sc_hd__decap_12
XTAP_2007 VGND VPWR sky130_fd_sc_hd__tapvpwrvgnd_1
XTAP_2018 VGND VPWR sky130_fd_sc_hd__tapvpwrvgnd_1
XTAP_2029 VGND VPWR sky130_fd_sc_hd__tapvpwrvgnd_1
XTAP_1328 VGND VPWR sky130_fd_sc_hd__tapvpwrvgnd_1
XTAP_1317 VGND VPWR sky130_fd_sc_hd__tapvpwrvgnd_1
XTAP_1339 VGND VPWR sky130_fd_sc_hd__tapvpwrvgnd_1
XFILLER_0_77_641 VGND VGND VPWR VPWR sky130_fd_sc_hd__decap_4
XTAP_1306 VGND VPWR sky130_fd_sc_hd__tapvpwrvgnd_1
XFILLER_0_210_978 VGND VGND VPWR VPWR sky130_fd_sc_hd__fill_2
XFILLER_0_221_293 VPWR VGND VPWR VGND sky130_ef_sc_hd__decap_12
XFILLER_0_204_49 VGND VGND VPWR VPWR sky130_fd_sc_hd__fill_1
XFILLER_0_204_27 VGND VGND VPWR VPWR sky130_fd_sc_hd__fill_1
XFILLER_0_108_905 VPWR VGND VPWR VGND sky130_ef_sc_hd__decap_12
XFILLER_0_108_949 VPWR VGND VPWR VGND sky130_ef_sc_hd__decap_12
XFILLER_0_92_655 VGND VGND VPWR VPWR sky130_fd_sc_hd__decap_4
XFILLER_0_45_593 VPWR VGND VPWR VGND sky130_ef_sc_hd__decap_12
XFILLER_0_27_1237 VPWR VGND VPWR VGND sky130_ef_sc_hd__decap_12
XFILLER_0_66_1275 VGND VGND VPWR VPWR sky130_fd_sc_hd__decap_6
XFILLER_0_2_3 VPWR VGND VPWR VGND sky130_ef_sc_hd__decap_12
XFILLER_0_176_1263 VPWR VGND VPWR VGND sky130_ef_sc_hd__decap_12
XFILLER_0_137_1225 VPWR VGND VPWR VGND sky130_ef_sc_hd__decap_12
XFILLER_0_73_1213 VPWR VGND VPWR VGND sky130_ef_sc_hd__decap_12
XFILLER_0_213_1113 VGND VGND VPWR VPWR sky130_fd_sc_hd__decap_6
XTAP_2563 VGND VPWR sky130_fd_sc_hd__tapvpwrvgnd_1
XFILLER_0_213_783 VGND VGND VPWR VPWR sky130_fd_sc_hd__fill_1
XTAP_2552 VGND VPWR sky130_fd_sc_hd__tapvpwrvgnd_1
XTAP_2541 VGND VPWR sky130_fd_sc_hd__tapvpwrvgnd_1
XTAP_2530 VGND VPWR sky130_fd_sc_hd__tapvpwrvgnd_1
XFILLER_0_73_1279 VPWR VGND VPWR VGND sky130_ef_sc_hd__decap_12
XFILLER_0_213_1157 VPWR VGND VPWR VGND sky130_ef_sc_hd__decap_12
XTAP_2585 VGND VPWR sky130_fd_sc_hd__tapvpwrvgnd_1
XTAP_2574 VGND VPWR sky130_fd_sc_hd__tapvpwrvgnd_1
XTAP_2596 VGND VPWR sky130_fd_sc_hd__tapvpwrvgnd_1
XTAP_1840 VGND VPWR sky130_fd_sc_hd__tapvpwrvgnd_1
XTAP_1851 VGND VPWR sky130_fd_sc_hd__tapvpwrvgnd_1
XFILLER_0_114_27 VGND VGND VPWR VPWR sky130_fd_sc_hd__fill_1
XTAP_1873 VGND VPWR sky130_fd_sc_hd__tapvpwrvgnd_1
XTAP_1862 VGND VPWR sky130_fd_sc_hd__tapvpwrvgnd_1
XFILLER_0_23_47 VGND VGND VPWR VPWR sky130_fd_sc_hd__fill_1
XTAP_1884 VGND VPWR sky130_fd_sc_hd__tapvpwrvgnd_1
XTAP_1895 VGND VPWR sky130_fd_sc_hd__tapvpwrvgnd_1
XFILLER_0_183_1201 VPWR VGND VPWR VGND sky130_ef_sc_hd__decap_12
XFILLER_0_148_1343 VGND VGND VPWR VPWR sky130_fd_sc_hd__fill_1
XFILLER_0_130_15 VPWR VGND VPWR VGND sky130_ef_sc_hd__decap_12
XFILLER_0_36_593 VPWR VGND VPWR VGND sky130_ef_sc_hd__decap_12
XFILLER_0_10_1263 VPWR VGND VPWR VGND sky130_ef_sc_hd__decap_12
XFILLER_0_84_1331 VGND VGND VPWR VPWR sky130_fd_sc_hd__decap_6
XFILLER_0_113_429 VPWR VGND VPWR VGND sky130_ef_sc_hd__decap_12
XFILLER_0_183_1267 VPWR VGND VPWR VGND sky130_ef_sc_hd__decap_12
XFILLER_0_224_1253 VGND VGND VPWR VPWR sky130_fd_sc_hd__decap_6
XFILLER_0_210_81 VGND VGND VPWR VPWR sky130_fd_sc_hd__decap_3
XFILLER_0_80_1239 VPWR VGND VPWR VGND sky130_ef_sc_hd__decap_12
XFILLER_0_224_1297 VPWR VGND VPWR VGND sky130_ef_sc_hd__decap_12
XFILLER_0_220_1117 VPWR VGND VPWR VGND sky130_ef_sc_hd__decap_12
XFILLER_0_120_1251 VPWR VGND VPWR VGND sky130_ef_sc_hd__decap_12
XFILLER_0_223_503 VGND VGND VPWR VPWR sky130_fd_sc_hd__fill_1
XFILLER_0_155_1303 VGND VGND VPWR VPWR sky130_fd_sc_hd__decap_6
XFILLER_0_120_1295 VPWR VGND VPWR VGND sky130_ef_sc_hd__decap_12
XFILLER_0_3_35 VPWR VGND VPWR VGND sky130_ef_sc_hd__decap_12
XFILLER_0_218_1035 VGND VGND VPWR VPWR sky130_fd_sc_hd__fill_1
XFILLER_0_190_1227 VPWR VGND VPWR VGND sky130_ef_sc_hd__decap_12
XFILLER_0_3_57 VPWR VGND VPWR VGND sky130_ef_sc_hd__decap_12
XFILLER_0_211_709 VPWR VGND VPWR VGND sky130_ef_sc_hd__decap_12
XFILLER_0_91_1335 VGND VGND VPWR VPWR sky130_fd_sc_hd__decap_8
XFILLER_0_59_641 VGND VGND VPWR VPWR sky130_fd_sc_hd__decap_4
XFILLER_0_52_1319 VPWR VGND VPWR VGND sky130_ef_sc_hd__decap_12
XFILLER_0_114_1033 VGND VGND VPWR VPWR sky130_fd_sc_hd__decap_3
XFILLER_0_4_1117 VPWR VGND VPWR VGND sky130_ef_sc_hd__decap_12
XFILLER_0_8_1275 VGND VGND VPWR VPWR sky130_fd_sc_hd__decap_6
XFILLER_0_171_22 VPWR VGND VPWR VGND sky130_ef_sc_hd__decap_12
XFILLER_0_191_605 VPWR VGND VPWR VGND sky130_ef_sc_hd__decap_12
XFILLER_0_114_1077 VPWR VGND VPWR VGND sky130_ef_sc_hd__decap_12
XFILLER_0_89_1253 VGND VGND VPWR VPWR sky130_fd_sc_hd__fill_1
XFILLER_0_74_655 VGND VGND VPWR VPWR sky130_fd_sc_hd__decap_4
XFILLER_0_6_421 VPWR VGND VPWR VGND sky130_ef_sc_hd__decap_12
XFILLER_0_7_977 VGND VGND VPWR VPWR sky130_fd_sc_hd__decap_3
XFILLER_0_162_1307 VPWR VGND VPWR VGND sky130_ef_sc_hd__decap_12
XFILLER_0_27_593 VPWR VGND VPWR VGND sky130_ef_sc_hd__decap_12
XFILLER_0_219_809 VPWR VGND VPWR VGND sky130_ef_sc_hd__decap_12
XFILLER_0_196_41 VGND VGND VPWR VPWR sky130_fd_sc_hd__decap_8
XFILLER_0_2_693 VGND VGND VPWR VPWR sky130_fd_sc_hd__decap_6
XFILLER_0_1_181 VPWR VGND VPWR VGND sky130_ef_sc_hd__decap_12
XFILLER_0_26_1281 VGND VGND VPWR VPWR sky130_fd_sc_hd__fill_1
XFILLER_0_226_330 VGND VGND VPWR VPWR sky130_fd_sc_hd__fill_1
XFILLER_0_96_1213 VPWR VGND VPWR VGND sky130_ef_sc_hd__decap_12
XFILLER_0_214_525 VGND VGND VPWR VPWR sky130_fd_sc_hd__decap_6
XFILLER_0_214_569 VPWR VGND VPWR VGND sky130_ef_sc_hd__decap_12
XFILLER_0_215_15 VPWR VGND VPWR VGND sky130_ef_sc_hd__decap_12
XFILLER_0_210_753 VGND VGND VPWR VPWR sky130_fd_sc_hd__decap_3
XPHY_912 VGND VGND VPWR VPWR sky130_fd_sc_hd__decap_3
XPHY_901 VGND VGND VPWR VPWR sky130_fd_sc_hd__decap_3
XFILLER_0_210_797 VPWR VGND VPWR VGND sky130_ef_sc_hd__decap_12
XFILLER_0_182_605 VPWR VGND VPWR VGND sky130_ef_sc_hd__decap_12
XPHY_934 VGND VGND VPWR VPWR sky130_fd_sc_hd__decap_3
XPHY_923 VGND VGND VPWR VPWR sky130_fd_sc_hd__decap_3
XPHY_945 VGND VGND VPWR VPWR sky130_fd_sc_hd__decap_3
XPHY_978 VGND VGND VPWR VPWR sky130_fd_sc_hd__decap_3
XPHY_967 VGND VGND VPWR VPWR sky130_fd_sc_hd__decap_3
XFILLER_0_108_713 VPWR VGND VPWR VGND sky130_ef_sc_hd__decap_12
XFILLER_0_65_655 VGND VGND VPWR VPWR sky130_fd_sc_hd__fill_2
XPHY_956 VGND VGND VPWR VPWR sky130_fd_sc_hd__decap_3
XPHY_989 VGND VGND VPWR VPWR sky130_fd_sc_hd__decap_3
XFILLER_0_108_757 VPWR VGND VPWR VGND sky130_ef_sc_hd__decap_12
XFILLER_0_68_1337 VGND VGND VPWR VPWR sky130_fd_sc_hd__fill_1
XFILLER_0_107_223 VGND VGND VPWR VPWR sky130_fd_sc_hd__fill_1
XFILLER_0_18_593 VPWR VGND VPWR VGND sky130_ef_sc_hd__decap_12
XFILLER_0_100_29 VPWR VGND VPWR VGND sky130_ef_sc_hd__decap_12
XANTENNA_input64_A psum_col0_in[8] VGND VGND VPWR VPWR sky130_fd_sc_hd__diode_2
XFILLER_0_104_1257 VGND VGND VPWR VPWR sky130_fd_sc_hd__decap_3
XFILLER_0_40_1201 VPWR VGND VPWR VGND sky130_ef_sc_hd__decap_12
XFILLER_0_109_27 VPWR VGND VPWR VGND sky130_ef_sc_hd__decap_12
XFILLER_0_139_1309 VGND VGND VPWR VPWR sky130_fd_sc_hd__fill_1
XFILLER_0_217_385 VGND VGND VPWR VPWR sky130_fd_sc_hd__decap_6
XANTENNA_output220_A net220 VGND VGND VPWR VPWR sky130_fd_sc_hd__diode_2
XFILLER_0_125_15 VPWR VGND VPWR VGND sky130_ef_sc_hd__decap_12
XTAP_2371 VGND VPWR sky130_fd_sc_hd__tapvpwrvgnd_1
XTAP_2360 VGND VPWR sky130_fd_sc_hd__tapvpwrvgnd_1
XFILLER_0_140_6 VGND VGND VPWR VPWR sky130_fd_sc_hd__fill_2
XTAP_2382 VGND VPWR sky130_fd_sc_hd__tapvpwrvgnd_1
XTAP_2393 VGND VPWR sky130_fd_sc_hd__tapvpwrvgnd_1
XFILLER_0_173_605 VPWR VGND VPWR VGND sky130_ef_sc_hd__decap_12
XFILLER_0_56_655 VGND VGND VPWR VPWR sky130_fd_sc_hd__decap_4
XTAP_1670 VGND VPWR sky130_fd_sc_hd__tapvpwrvgnd_1
XTAP_1681 VGND VPWR sky130_fd_sc_hd__tapvpwrvgnd_1
XTAP_1692 VGND VPWR sky130_fd_sc_hd__tapvpwrvgnd_1
XFILLER_0_141_47 VGND VGND VPWR VPWR sky130_fd_sc_hd__decap_3
XFILLER_0_4_925 VPWR VGND VPWR VGND sky130_ef_sc_hd__decap_12
XFILLER_0_71_647 VGND VGND VPWR VPWR sky130_fd_sc_hd__decap_8
XFILLER_0_109_1113 VGND VGND VPWR VPWR sky130_fd_sc_hd__decap_6
XFILLER_0_113_237 VPWR VGND VPWR VGND sky130_ef_sc_hd__decap_12
XFILLER_0_109_1157 VPWR VGND VPWR VGND sky130_ef_sc_hd__decap_12
XFILLER_0_224_1061 VPWR VGND VPWR VGND sky130_ef_sc_hd__decap_12
XANTENNA_u_pe00_act_in[4] net11 VGND VGND VPWR VPWR sky130_fd_sc_hd__diode_2
XFILLER_0_224_867 VGND VGND VPWR VPWR sky130_fd_sc_hd__fill_1
XFILLER_0_159_1291 VPWR VGND VPWR VGND sky130_ef_sc_hd__decap_12
XFILLER_0_211_517 VPWR VGND VPWR VGND sky130_ef_sc_hd__decap_12
XFILLER_0_56_1263 VPWR VGND VPWR VGND sky130_ef_sc_hd__decap_12
XFILLER_0_17_1225 VPWR VGND VPWR VGND sky130_ef_sc_hd__decap_12
XFILLER_0_164_605 VPWR VGND VPWR VGND sky130_ef_sc_hd__decap_12
XPHY_208 VGND VGND VPWR VPWR sky130_fd_sc_hd__decap_3
XPHY_219 VGND VGND VPWR VPWR sky130_fd_sc_hd__decap_3
XFILLER_0_47_655 VGND VGND VPWR VPWR sky130_fd_sc_hd__fill_2
XFILLER_0_7_741 VPWR VGND VPWR VGND sky130_ef_sc_hd__decap_12
XFILLER_0_201_39 VGND VGND VPWR VPWR sky130_fd_sc_hd__decap_8
XFILLER_0_105_727 VGND VGND VPWR VPWR sky130_fd_sc_hd__fill_1
XFILLER_0_6_251 VGND VGND VPWR VPWR sky130_fd_sc_hd__fill_1
XFILLER_0_7_785 VPWR VGND VPWR VGND sky130_ef_sc_hd__decap_12
XFILLER_0_166_1251 VPWR VGND VPWR VGND sky130_ef_sc_hd__decap_12
XFILLER_0_127_1213 VPWR VGND VPWR VGND sky130_ef_sc_hd__decap_12
XFILLER_0_104_237 VPWR VGND VPWR VGND sky130_ef_sc_hd__decap_12
XFILLER_0_166_1295 VPWR VGND VPWR VGND sky130_ef_sc_hd__decap_12
XFILLER_0_28_1343 VGND VGND VPWR VPWR sky130_fd_sc_hd__fill_1
XFILLER_0_63_1201 VPWR VGND VPWR VGND sky130_ef_sc_hd__decap_12
XFILLER_0_127_1279 VPWR VGND VPWR VGND sky130_ef_sc_hd__decap_12
XFILLER_0_63_1267 VPWR VGND VPWR VGND sky130_ef_sc_hd__decap_12
XFILLER_0_219_617 VPWR VGND VPWR VGND sky130_ef_sc_hd__decap_12
XFILLER_0_98_1319 VPWR VGND VPWR VGND sky130_ef_sc_hd__decap_12
XFILLER_0_226_182 VPWR VGND VPWR VGND sky130_ef_sc_hd__decap_12
XFILLER_0_226_160 VGND VGND VPWR VPWR sky130_fd_sc_hd__decap_8
XFILLER_0_214_333 VPWR VGND VPWR VGND sky130_ef_sc_hd__decap_12
XFILLER_0_138_1331 VGND VGND VPWR VPWR sky130_fd_sc_hd__decap_6
XFILLER_0_215_889 VGND VGND VPWR VPWR sky130_fd_sc_hd__decap_6
XFILLER_0_214_377 VPWR VGND VPWR VGND sky130_ef_sc_hd__decap_12
XFILLER_0_173_1255 VPWR VGND VPWR VGND sky130_ef_sc_hd__decap_12
XFILLER_0_35_1303 VGND VGND VPWR VPWR sky130_fd_sc_hd__decap_6
XFILLER_0_214_1241 VPWR VGND VPWR VGND sky130_ef_sc_hd__decap_12
XFILLER_0_134_1239 VPWR VGND VPWR VGND sky130_ef_sc_hd__decap_12
XFILLER_0_70_1227 VPWR VGND VPWR VGND sky130_ef_sc_hd__decap_12
XFILLER_0_214_1285 VPWR VGND VPWR VGND sky130_ef_sc_hd__decap_12
XFILLER_0_210_1105 VPWR VGND VPWR VGND sky130_ef_sc_hd__decap_12
XFILLER_0_210_561 VPWR VGND VPWR VGND sky130_ef_sc_hd__decap_12
XPHY_720 VGND VGND VPWR VPWR sky130_fd_sc_hd__decap_3
XFILLER_0_155_605 VPWR VGND VPWR VGND sky130_ef_sc_hd__decap_12
XFILLER_0_210_1149 VGND VGND VPWR VPWR sky130_fd_sc_hd__fill_2
XPHY_731 VGND VGND VPWR VPWR sky130_fd_sc_hd__decap_3
XPHY_742 VGND VGND VPWR VPWR sky130_fd_sc_hd__decap_3
XFILLER_0_38_655 VGND VGND VPWR VPWR sky130_fd_sc_hd__decap_4
XPHY_753 VGND VGND VPWR VPWR sky130_fd_sc_hd__decap_3
XPHY_786 VGND VGND VPWR VPWR sky130_fd_sc_hd__decap_3
XPHY_775 VGND VGND VPWR VPWR sky130_fd_sc_hd__decap_3
XPHY_764 VGND VGND VPWR VPWR sky130_fd_sc_hd__decap_3
XFILLER_0_110_1261 VPWR VGND VPWR VGND sky130_ef_sc_hd__decap_12
XFILLER_0_170_619 VPWR VGND VPWR VGND sky130_ef_sc_hd__decap_12
XPHY_797 VGND VGND VPWR VPWR sky130_fd_sc_hd__decap_3
XFILLER_0_20_15 VPWR VGND VPWR VGND sky130_ef_sc_hd__decap_12
XFILLER_0_53_647 VGND VGND VPWR VPWR sky130_fd_sc_hd__decap_8
XFILLER_0_108_587 VGND VGND VPWR VPWR sky130_fd_sc_hd__fill_1
XFILLER_0_111_39 VPWR VGND VPWR VGND sky130_ef_sc_hd__decap_12
XFILLER_0_145_1335 VGND VGND VPWR VPWR sky130_fd_sc_hd__decap_8
XFILLER_0_81_1323 VPWR VGND VPWR VGND sky130_ef_sc_hd__decap_12
XFILLER_0_221_1201 VPWR VGND VPWR VGND sky130_ef_sc_hd__decap_12
XFILLER_0_0_405 VPWR VGND VPWR VGND sky130_ef_sc_hd__decap_12
XFILLER_0_0_427 VPWR VGND VPWR VGND sky130_ef_sc_hd__decap_12
XFILLER_0_42_1307 VPWR VGND VPWR VGND sky130_ef_sc_hd__decap_12
XFILLER_0_221_1245 VPWR VGND VPWR VGND sky130_ef_sc_hd__decap_12
XFILLER_0_104_1021 VPWR VGND VPWR VGND sky130_ef_sc_hd__decap_12
XFILLER_0_221_1289 VPWR VGND VPWR VGND sky130_ef_sc_hd__decap_12
XFILLER_0_225_609 VGND VGND VPWR VPWR sky130_fd_sc_hd__decap_6
XFILLER_0_104_1065 VPWR VGND VPWR VGND sky130_ef_sc_hd__decap_12
XFILLER_0_191_1311 VPWR VGND VPWR VGND sky130_ef_sc_hd__decap_12
XFILLER_0_217_193 VPWR VGND VPWR VGND sky130_ef_sc_hd__decap_12
XFILLER_0_45_45 VGND VGND VPWR VPWR sky130_fd_sc_hd__decap_3
XFILLER_0_152_1339 VGND VGND VPWR VPWR sky130_fd_sc_hd__decap_4
XFILLER_0_146_605 VPWR VGND VPWR VGND sky130_ef_sc_hd__decap_12
XFILLER_0_5_1201 VPWR VGND VPWR VGND sky130_ef_sc_hd__decap_12
XTAP_2190 VGND VPWR sky130_fd_sc_hd__tapvpwrvgnd_1
XFILLER_0_29_655 VGND VGND VPWR VPWR sky130_fd_sc_hd__fill_2
XFILLER_0_5_1245 VPWR VGND VPWR VGND sky130_ef_sc_hd__decap_12
XFILLER_0_5_1289 VPWR VGND VPWR VGND sky130_ef_sc_hd__decap_12
XFILLER_0_86_1201 VPWR VGND VPWR VGND sky130_ef_sc_hd__decap_12
XFILLER_0_114_557 VGND VGND VPWR VPWR sky130_fd_sc_hd__decap_3
XFILLER_0_4_755 VGND VGND VPWR VPWR sky130_fd_sc_hd__fill_1
XFILLER_0_200_1307 VPWR VGND VPWR VGND sky130_ef_sc_hd__decap_12
XFILLER_0_86_41 VGND VGND VPWR VPWR sky130_fd_sc_hd__decap_8
XFILLER_0_43_3 VPWR VGND VPWR VGND sky130_ef_sc_hd__decap_12
XFILLER_0_19_1309 VGND VGND VPWR VPWR sky130_fd_sc_hd__fill_1
XFILLER_0_212_837 VPWR VGND VPWR VGND sky130_ef_sc_hd__decap_12
XFILLER_0_93_1249 VGND VGND VPWR VPWR sky130_fd_sc_hd__decap_4
XFILLER_0_220_881 VPWR VGND VPWR VGND sky130_ef_sc_hd__decap_12
XFILLER_0_137_605 VPWR VGND VPWR VGND sky130_ef_sc_hd__decap_12
XFILLER_0_109_329 VGND VGND VPWR VPWR sky130_fd_sc_hd__decap_6
XFILLER_0_212_27 VGND VGND VPWR VPWR sky130_fd_sc_hd__fill_1
XFILLER_0_152_619 VPWR VGND VPWR VGND sky130_ef_sc_hd__decap_12
XFILLER_0_35_647 VGND VGND VPWR VPWR sky130_fd_sc_hd__decap_8
XFILLER_0_50_617 VGND VGND VPWR VPWR sky130_fd_sc_hd__fill_1
XFILLER_0_219_447 VGND VGND VPWR VPWR sky130_fd_sc_hd__fill_1
XFILLER_0_101_1249 VGND VGND VPWR VPWR sky130_fd_sc_hd__decap_4
XFILLER_0_215_653 VPWR VGND VPWR VGND sky130_ef_sc_hd__decap_12
XFILLER_0_214_141 VPWR VGND VPWR VGND sky130_ef_sc_hd__decap_12
XANTENNA_input27_A act_row1_in[4] VGND VGND VPWR VPWR sky130_fd_sc_hd__diode_2
XFILLER_0_215_697 VPWR VGND VPWR VGND sky130_ef_sc_hd__decap_12
XFILLER_0_15_15 VPWR VGND VPWR VGND sky130_ef_sc_hd__decap_12
XFILLER_0_39_1291 VPWR VGND VPWR VGND sky130_ef_sc_hd__decap_12
XFILLER_0_214_1093 VPWR VGND VPWR VGND sky130_ef_sc_hd__decap_12
XFILLER_0_128_605 VPWR VGND VPWR VGND sky130_ef_sc_hd__decap_12
XFILLER_0_195_593 VPWR VGND VPWR VGND sky130_ef_sc_hd__decap_12
XPHY_561 VGND VGND VPWR VPWR sky130_fd_sc_hd__decap_3
XFILLER_0_109_841 VPWR VGND VPWR VGND sky130_ef_sc_hd__decap_12
XFILLER_0_31_25 VPWR VGND VPWR VGND sky130_ef_sc_hd__decap_12
XPHY_550 VGND VGND VPWR VPWR sky130_fd_sc_hd__decap_3
XPHY_572 VGND VGND VPWR VPWR sky130_fd_sc_hd__decap_3
XPHY_583 VGND VGND VPWR VPWR sky130_fd_sc_hd__decap_3
XPHY_594 VGND VGND VPWR VPWR sky130_fd_sc_hd__decap_3
XFILLER_0_122_49 VGND VGND VPWR VPWR sky130_fd_sc_hd__fill_1
XPHY_1193 VGND VGND VPWR VPWR sky130_fd_sc_hd__decap_3
XPHY_1171 VGND VGND VPWR VPWR sky130_fd_sc_hd__decap_3
XPHY_1182 VGND VGND VPWR VPWR sky130_fd_sc_hd__decap_3
XPHY_1160 VGND VGND VPWR VPWR sky130_fd_sc_hd__decap_3
XFILLER_0_110_1091 VGND VGND VPWR VPWR sky130_fd_sc_hd__fill_1
XFILLER_0_41_617 VPWR VGND VPWR VGND sky130_ef_sc_hd__decap_12
XFILLER_0_0_1131 VPWR VGND VPWR VGND sky130_ef_sc_hd__decap_12
XFILLER_0_151_641 VGND VGND VPWR VPWR sky130_fd_sc_hd__decap_4
XFILLER_0_0_1175 VGND VGND VPWR VPWR sky130_fd_sc_hd__fill_1
XFILLER_0_0_1197 VGND VGND VPWR VPWR sky130_fd_sc_hd__decap_6
XFILLER_0_106_1105 VPWR VGND VPWR VGND sky130_ef_sc_hd__decap_12
XFILLER_0_111_505 VPWR VGND VPWR VGND sky130_ef_sc_hd__decap_12
XFILLER_0_46_1251 VPWR VGND VPWR VGND sky130_ef_sc_hd__decap_12
XFILLER_0_106_1149 VPWR VGND VPWR VGND sky130_ef_sc_hd__decap_12
XFILLER_0_0_279 VGND VGND VPWR VPWR sky130_fd_sc_hd__fill_1
XFILLER_0_46_1295 VPWR VGND VPWR VGND sky130_ef_sc_hd__decap_12
XFILLER_0_225_417 VPWR VGND VPWR VGND sky130_ef_sc_hd__decap_12
XFILLER_0_206_631 VPWR VGND VPWR VGND sky130_ef_sc_hd__decap_12
XFILLER_0_186_3 VPWR VGND VPWR VGND sky130_ef_sc_hd__decap_12
XFILLER_0_147_46 VGND VGND VPWR VPWR sky130_fd_sc_hd__decap_4
XFILLER_0_117_1201 VPWR VGND VPWR VGND sky130_ef_sc_hd__decap_12
XFILLER_0_220_133 VGND VGND VPWR VPWR sky130_fd_sc_hd__decap_6
XFILLER_0_156_1283 VPWR VGND VPWR VGND sky130_ef_sc_hd__decap_12
XFILLER_0_18_1331 VGND VGND VPWR VPWR sky130_fd_sc_hd__decap_6
XFILLER_0_117_1267 VPWR VGND VPWR VGND sky130_ef_sc_hd__decap_12
XFILLER_0_7_1329 VPWR VGND VPWR VGND sky130_ef_sc_hd__decap_12
XFILLER_0_220_177 VPWR VGND VPWR VGND sky130_ef_sc_hd__decap_12
XFILLER_0_119_605 VPWR VGND VPWR VGND sky130_ef_sc_hd__decap_12
XFILLER_0_14_1239 VPWR VGND VPWR VGND sky130_ef_sc_hd__decap_12
XFILLER_0_53_1255 VPWR VGND VPWR VGND sky130_ef_sc_hd__decap_12
XFILLER_0_186_593 VPWR VGND VPWR VGND sky130_ef_sc_hd__decap_12
XFILLER_0_88_1307 VPWR VGND VPWR VGND sky130_ef_sc_hd__decap_12
XFILLER_0_134_619 VPWR VGND VPWR VGND sky130_ef_sc_hd__decap_12
XFILLER_0_17_647 VPWR VGND VPWR VGND sky130_ef_sc_hd__decap_12
XFILLER_0_32_617 VGND VGND VPWR VPWR sky130_fd_sc_hd__fill_1
XFILLER_0_114_321 VPWR VGND VPWR VGND sky130_ef_sc_hd__decap_12
XANTENNA_u_pe00_rst_n net98 VGND VGND VPWR VPWR sky130_fd_sc_hd__diode_2
XFILLER_0_114_365 VPWR VGND VPWR VGND sky130_ef_sc_hd__decap_12
XFILLER_0_124_1227 VPWR VGND VPWR VGND sky130_ef_sc_hd__decap_12
XFILLER_0_25_1335 VGND VGND VPWR VPWR sky130_fd_sc_hd__decap_8
XFILLER_0_204_1251 VPWR VGND VPWR VGND sky130_ef_sc_hd__decap_12
XFILLER_0_198_1339 VGND VGND VPWR VPWR sky130_fd_sc_hd__decap_4
XFILLER_0_204_1295 VPWR VGND VPWR VGND sky130_ef_sc_hd__decap_12
XFILLER_0_225_951 VGND VGND VPWR VPWR sky130_fd_sc_hd__fill_1
XFILLER_0_207_27 VPWR VGND VPWR VGND sky130_ef_sc_hd__decap_12
XFILLER_0_99_617 VPWR VGND VPWR VGND sky130_ef_sc_hd__decap_12
XFILLER_0_212_601 VPWR VGND VPWR VGND sky130_ef_sc_hd__decap_12
XTAP_2904 VGND VPWR sky130_fd_sc_hd__tapvpwrvgnd_1
XTAP_2915 VGND VPWR sky130_fd_sc_hd__tapvpwrvgnd_1
XTAP_2937 VGND VPWR sky130_fd_sc_hd__tapvpwrvgnd_1
XFILLER_0_212_645 VPWR VGND VPWR VGND sky130_ef_sc_hd__decap_12
XTAP_2926 VGND VPWR sky130_fd_sc_hd__tapvpwrvgnd_1
XFILLER_0_211_111 VGND VGND VPWR VPWR sky130_fd_sc_hd__fill_1
XFILLER_0_170_1225 VGND VGND VPWR VPWR sky130_fd_sc_hd__fill_1
XFILLER_0_135_1323 VPWR VGND VPWR VGND sky130_ef_sc_hd__decap_12
XTAP_2959 VGND VPWR sky130_fd_sc_hd__tapvpwrvgnd_1
XTAP_2948 VGND VPWR sky130_fd_sc_hd__tapvpwrvgnd_1
XFILLER_0_223_15 VPWR VGND VPWR VGND sky130_ef_sc_hd__decap_12
XFILLER_0_71_1311 VPWR VGND VPWR VGND sky130_ef_sc_hd__decap_12
XFILLER_0_211_1233 VPWR VGND VPWR VGND sky130_ef_sc_hd__decap_12
XFILLER_0_177_593 VPWR VGND VPWR VGND sky130_ef_sc_hd__decap_12
XFILLER_0_32_1339 VGND VGND VPWR VPWR sky130_fd_sc_hd__decap_4
XFILLER_0_109_137 VPWR VGND VPWR VGND sky130_ef_sc_hd__decap_12
XFILLER_0_106_811 VGND VGND VPWR VPWR sky130_fd_sc_hd__fill_1
XFILLER_0_133_641 VGND VGND VPWR VPWR sky130_fd_sc_hd__decap_4
XFILLER_0_23_617 VPWR VGND VPWR VGND sky130_ef_sc_hd__decap_12
XFILLER_0_181_1343 VGND VGND VPWR VPWR sky130_fd_sc_hd__fill_1
XFILLER_0_101_593 VPWR VGND VPWR VGND sky130_ef_sc_hd__decap_12
XFILLER_0_117_27 VPWR VGND VPWR VGND sky130_ef_sc_hd__decap_12
XFILLER_0_216_973 VGND VGND VPWR VPWR sky130_fd_sc_hd__decap_6
XFILLER_0_215_461 VPWR VGND VPWR VGND sky130_ef_sc_hd__decap_12
XFILLER_0_203_645 VGND VGND VPWR VPWR sky130_fd_sc_hd__fill_1
XFILLER_0_42_13 VPWR VGND VPWR VGND sky130_ef_sc_hd__decap_12
XFILLER_0_168_593 VPWR VGND VPWR VGND sky130_ef_sc_hd__decap_12
XFILLER_0_213_81 VPWR VGND VPWR VGND sky130_ef_sc_hd__decap_12
XFILLER_0_116_619 VPWR VGND VPWR VGND sky130_ef_sc_hd__decap_12
XPHY_380 VGND VGND VPWR VPWR sky130_fd_sc_hd__decap_3
XFILLER_0_112_1197 VGND VGND VPWR VPWR sky130_fd_sc_hd__decap_6
XFILLER_0_109_671 VGND VGND VPWR VPWR sky130_fd_sc_hd__fill_1
XFILLER_0_5_305 VPWR VGND VPWR VGND sky130_ef_sc_hd__decap_12
XPHY_391 VGND VGND VPWR VPWR sky130_fd_sc_hd__decap_3
XFILLER_0_2_1259 VGND VGND VPWR VPWR sky130_fd_sc_hd__fill_1
XFILLER_0_147_1249 VGND VGND VPWR VPWR sky130_fd_sc_hd__decap_4
XFILLER_0_5_349 VPWR VGND VPWR VGND sky130_ef_sc_hd__decap_12
XFILLER_0_14_617 VGND VGND VPWR VPWR sky130_fd_sc_hd__fill_1
XFILLER_0_112_825 VPWR VGND VPWR VGND sky130_ef_sc_hd__decap_12
XFILLER_0_83_1237 VPWR VGND VPWR VGND sky130_ef_sc_hd__decap_12
XFILLER_0_112_869 VPWR VGND VPWR VGND sky130_ef_sc_hd__decap_12
XFILLER_0_111_335 VGND VGND VPWR VPWR sky130_fd_sc_hd__fill_1
XFILLER_0_226_748 VGND VGND VPWR VPWR sky130_fd_sc_hd__fill_1
XFILLER_0_225_225 VPWR VGND VPWR VGND sky130_ef_sc_hd__decap_12
XFILLER_0_193_1225 VPWR VGND VPWR VGND sky130_ef_sc_hd__decap_12
XPHY_28 VGND VGND VPWR VPWR sky130_fd_sc_hd__decap_3
XPHY_17 VGND VGND VPWR VPWR sky130_fd_sc_hd__decap_3
XFILLER_0_107_93 VPWR VGND VPWR VGND sky130_ef_sc_hd__decap_12
XFILLER_0_221_497 VGND VGND VPWR VPWR sky130_fd_sc_hd__decap_6
XPHY_39 VGND VGND VPWR VPWR sky130_fd_sc_hd__decap_3
XFILLER_0_159_593 VPWR VGND VPWR VGND sky130_ef_sc_hd__decap_12
XFILLER_0_130_1275 VGND VGND VPWR VPWR sky130_fd_sc_hd__decap_6
XFILLER_0_115_641 VGND VGND VPWR VPWR sky130_fd_sc_hd__decap_4
XFILLER_0_130_655 VGND VGND VPWR VPWR sky130_fd_sc_hd__decap_4
XFILLER_0_218_15 VPWR VGND VPWR VGND sky130_ef_sc_hd__decap_12
XFILLER_0_99_1255 VPWR VGND VPWR VGND sky130_ef_sc_hd__decap_12
XFILLER_0_213_921 VPWR VGND VPWR VGND sky130_ef_sc_hd__decap_12
XTAP_2701 VGND VPWR sky130_fd_sc_hd__tapvpwrvgnd_1
XTAP_2712 VGND VPWR sky130_fd_sc_hd__tapvpwrvgnd_1
XANTENNA_input129_A w01[6] VGND VGND VPWR VPWR sky130_fd_sc_hd__diode_2
XTAP_2723 VGND VPWR sky130_fd_sc_hd__tapvpwrvgnd_1
XTAP_2745 VGND VPWR sky130_fd_sc_hd__tapvpwrvgnd_1
XFILLER_0_213_965 VPWR VGND VPWR VGND sky130_ef_sc_hd__decap_12
XTAP_2734 VGND VPWR sky130_fd_sc_hd__tapvpwrvgnd_1
XTAP_2778 VGND VPWR sky130_fd_sc_hd__tapvpwrvgnd_1
XTAP_2767 VGND VPWR sky130_fd_sc_hd__tapvpwrvgnd_1
XTAP_2756 VGND VPWR sky130_fd_sc_hd__tapvpwrvgnd_1
XFILLER_0_212_475 VGND VGND VPWR VPWR sky130_fd_sc_hd__fill_1
XTAP_2789 VGND VPWR sky130_fd_sc_hd__tapvpwrvgnd_1
XFILLER_0_36_1283 VPWR VGND VPWR VGND sky130_ef_sc_hd__decap_12
XFILLER_0_211_1063 VGND VGND VPWR VPWR sky130_fd_sc_hd__fill_1
XFILLER_0_12_27 VGND VGND VPWR VPWR sky130_fd_sc_hd__fill_1
XANTENNA_input94_A psum_col1_in[6] VGND VGND VPWR VPWR sky130_fd_sc_hd__diode_2
XFILLER_0_12_49 VGND VGND VPWR VPWR sky130_fd_sc_hd__fill_1
XFILLER_0_3_809 VPWR VGND VPWR VGND sky130_ef_sc_hd__decap_12
XFILLER_0_1_1281 VGND VGND VPWR VPWR sky130_fd_sc_hd__decap_6
XFILLER_0_107_1233 VPWR VGND VPWR VGND sky130_ef_sc_hd__decap_12
XFILLER_0_82_1281 VGND VGND VPWR VPWR sky130_fd_sc_hd__fill_1
XFILLER_0_128_15 VPWR VGND VPWR VGND sky130_ef_sc_hd__decap_12
XFILLER_0_78_1339 VGND VGND VPWR VPWR sky130_fd_sc_hd__decap_4
XFILLER_0_218_1217 VPWR VGND VPWR VGND sky130_ef_sc_hd__decap_12
XFILLER_0_223_729 VPWR VGND VPWR VGND sky130_ef_sc_hd__decap_12
XFILLER_0_216_781 VPWR VGND VPWR VGND sky130_ef_sc_hd__decap_12
Xinput160 w11[5] VGND VGND VPWR VPWR net160 sky130_fd_sc_hd__buf_4
XFILLER_0_188_655 VGND VGND VPWR VPWR sky130_fd_sc_hd__decap_4
XFILLER_0_153_1253 VGND VGND VPWR VPWR sky130_fd_sc_hd__fill_1
XFILLER_0_86_631 VPWR VGND VPWR VGND sky130_ef_sc_hd__decap_12
XFILLER_0_149_3 VPWR VGND VPWR VGND sky130_ef_sc_hd__decap_12
XFILLER_0_15_1323 VPWR VGND VPWR VGND sky130_ef_sc_hd__decap_12
XFILLER_0_50_1225 VGND VGND VPWR VPWR sky130_fd_sc_hd__fill_1
XFILLER_0_6_625 VPWR VGND VPWR VGND sky130_ef_sc_hd__decap_12
XFILLER_0_5_113 VPWR VGND VPWR VGND sky130_ef_sc_hd__decap_12
XFILLER_0_6_669 VPWR VGND VPWR VGND sky130_ef_sc_hd__decap_12
XFILLER_0_160_1213 VPWR VGND VPWR VGND sky130_ef_sc_hd__decap_12
XFILLER_0_125_1311 VPWR VGND VPWR VGND sky130_ef_sc_hd__decap_12
XFILLER_0_112_699 VGND VGND VPWR VPWR sky130_fd_sc_hd__fill_1
XFILLER_0_1_385 VGND VGND VPWR VPWR sky130_fd_sc_hd__decap_6
XFILLER_0_10_631 VPWR VGND VPWR VGND sky130_ef_sc_hd__decap_12
XFILLER_0_61_1343 VGND VGND VPWR VPWR sky130_fd_sc_hd__fill_1
XFILLER_0_195_1309 VGND VGND VPWR VPWR sky130_fd_sc_hd__fill_1
XFILLER_0_226_512 VPWR VGND VPWR VGND sky130_ef_sc_hd__decap_12
XFILLER_0_226_556 VGND VGND VPWR VPWR sky130_fd_sc_hd__decap_4
XFILLER_0_94_41 VGND VGND VPWR VPWR sky130_fd_sc_hd__decap_8
XFILLER_0_226_589 VGND VGND VPWR VPWR sky130_fd_sc_hd__decap_6
XFILLER_0_226_578 VGND VGND VPWR VPWR sky130_fd_sc_hd__decap_8
XFILLER_0_213_217 VGND VGND VPWR VPWR sky130_fd_sc_hd__decap_6
XFILLER_0_179_655 VGND VGND VPWR VPWR sky130_fd_sc_hd__fill_2
XTAP_2019 VGND VPWR sky130_fd_sc_hd__tapvpwrvgnd_1
XTAP_2008 VGND VPWR sky130_fd_sc_hd__tapvpwrvgnd_1
XFILLER_0_221_261 VPWR VGND VPWR VGND sky130_ef_sc_hd__decap_12
XTAP_1318 VGND VPWR sky130_fd_sc_hd__tapvpwrvgnd_1
XTAP_1307 VGND VPWR sky130_fd_sc_hd__tapvpwrvgnd_1
XTAP_1329 VGND VPWR sky130_fd_sc_hd__tapvpwrvgnd_1
XFILLER_0_210_957 VGND VGND VPWR VPWR sky130_fd_sc_hd__decap_8
XFILLER_0_132_1337 VGND VGND VPWR VPWR sky130_fd_sc_hd__fill_1
XFILLER_0_108_917 VGND VGND VPWR VPWR sky130_fd_sc_hd__decap_6
XFILLER_0_107_405 VPWR VGND VPWR VGND sky130_ef_sc_hd__decap_12
XFILLER_0_107_449 VPWR VGND VPWR VGND sky130_ef_sc_hd__decap_12
XFILLER_0_27_1249 VGND VGND VPWR VPWR sky130_fd_sc_hd__decap_4
XFILLER_0_176_1275 VGND VGND VPWR VPWR sky130_fd_sc_hd__decap_6
XFILLER_0_137_1237 VPWR VGND VPWR VGND sky130_ef_sc_hd__decap_12
XTAP_2520 VGND VPWR sky130_fd_sc_hd__tapvpwrvgnd_1
XFILLER_0_73_1225 VPWR VGND VPWR VGND sky130_ef_sc_hd__decap_12
XTAP_2553 VGND VPWR sky130_fd_sc_hd__tapvpwrvgnd_1
XTAP_2542 VGND VPWR sky130_fd_sc_hd__tapvpwrvgnd_1
XTAP_2531 VGND VPWR sky130_fd_sc_hd__tapvpwrvgnd_1
XFILLER_0_68_631 VPWR VGND VPWR VGND sky130_ef_sc_hd__decap_12
XFILLER_0_213_1169 VGND VGND VPWR VPWR sky130_fd_sc_hd__decap_6
XTAP_2564 VGND VPWR sky130_fd_sc_hd__tapvpwrvgnd_1
XTAP_2586 VGND VPWR sky130_fd_sc_hd__tapvpwrvgnd_1
XFILLER_0_185_647 VGND VGND VPWR VPWR sky130_fd_sc_hd__decap_8
XTAP_2575 VGND VPWR sky130_fd_sc_hd__tapvpwrvgnd_1
XTAP_2597 VGND VPWR sky130_fd_sc_hd__tapvpwrvgnd_1
XTAP_1830 VGND VPWR sky130_fd_sc_hd__tapvpwrvgnd_1
XFILLER_0_23_15 VPWR VGND VPWR VGND sky130_ef_sc_hd__decap_12
XTAP_1841 VGND VPWR sky130_fd_sc_hd__tapvpwrvgnd_1
XTAP_1852 VGND VPWR sky130_fd_sc_hd__tapvpwrvgnd_1
XTAP_1874 VGND VPWR sky130_fd_sc_hd__tapvpwrvgnd_1
XTAP_1863 VGND VPWR sky130_fd_sc_hd__tapvpwrvgnd_1
XTAP_1885 VGND VPWR sky130_fd_sc_hd__tapvpwrvgnd_1
XFILLER_0_113_1281 VGND VGND VPWR VPWR sky130_fd_sc_hd__decap_6
XTAP_1896 VGND VPWR sky130_fd_sc_hd__tapvpwrvgnd_1
XFILLER_0_83_645 VGND VGND VPWR VPWR sky130_fd_sc_hd__fill_1
XFILLER_0_3_1343 VGND VGND VPWR VPWR sky130_fd_sc_hd__fill_1
XFILLER_0_183_1213 VPWR VGND VPWR VGND sky130_ef_sc_hd__decap_12
XFILLER_0_114_909 VPWR VGND VPWR VGND sky130_ef_sc_hd__decap_12
XFILLER_0_130_27 VGND VGND VPWR VPWR sky130_fd_sc_hd__fill_1
XFILLER_0_3_617 VPWR VGND VPWR VGND sky130_ef_sc_hd__decap_12
XFILLER_0_10_1275 VGND VGND VPWR VPWR sky130_fd_sc_hd__decap_6
XFILLER_0_130_49 VGND VGND VPWR VPWR sky130_fd_sc_hd__fill_1
XFILLER_0_183_1279 VPWR VGND VPWR VGND sky130_ef_sc_hd__decap_12
XFILLER_0_84_1343 VGND VGND VPWR VPWR sky130_fd_sc_hd__fill_1
XFILLER_0_220_1129 VPWR VGND VPWR VGND sky130_ef_sc_hd__decap_12
XFILLER_0_107_1063 VGND VGND VPWR VPWR sky130_fd_sc_hd__fill_1
XFILLER_0_139_47 VGND VGND VPWR VPWR sky130_fd_sc_hd__decap_3
XFILLER_0_120_1263 VPWR VGND VPWR VGND sky130_ef_sc_hd__decap_12
XFILLER_0_194_1331 VGND VGND VPWR VPWR sky130_fd_sc_hd__decap_6
XFILLER_0_3_47 VGND VGND VPWR VPWR sky130_fd_sc_hd__decap_8
XFILLER_0_3_69 VPWR VGND VPWR VGND sky130_ef_sc_hd__decap_12
XFILLER_0_190_1239 VPWR VGND VPWR VGND sky130_ef_sc_hd__decap_12
XFILLER_0_223_559 VGND VGND VPWR VPWR sky130_fd_sc_hd__fill_1
XFILLER_0_210_209 VPWR VGND VPWR VGND sky130_ef_sc_hd__decap_12
XFILLER_0_91_1303 VGND VGND VPWR VPWR sky130_fd_sc_hd__decap_6
XFILLER_0_80_10 VPWR VGND VPWR VGND sky130_ef_sc_hd__decap_12
XFILLER_0_171_34 VPWR VGND VPWR VGND sky130_ef_sc_hd__decap_12
XFILLER_0_191_617 VPWR VGND VPWR VGND sky130_ef_sc_hd__decap_12
XFILLER_0_4_1129 VPWR VGND VPWR VGND sky130_ef_sc_hd__decap_12
XFILLER_0_114_1089 VGND VGND VPWR VPWR sky130_fd_sc_hd__decap_3
XFILLER_0_105_909 VPWR VGND VPWR VGND sky130_ef_sc_hd__decap_12
XFILLER_0_6_433 VPWR VGND VPWR VGND sky130_ef_sc_hd__decap_12
XFILLER_0_225_1007 VGND VGND VPWR VPWR sky130_fd_sc_hd__fill_1
XFILLER_0_6_477 VPWR VGND VPWR VGND sky130_ef_sc_hd__decap_12
XFILLER_0_162_1319 VPWR VGND VPWR VGND sky130_ef_sc_hd__decap_12
XFILLER_0_113_953 VPWR VGND VPWR VGND sky130_ef_sc_hd__decap_12
XFILLER_0_218_309 VPWR VGND VPWR VGND sky130_ef_sc_hd__decap_12
XFILLER_0_199_1253 VGND VGND VPWR VPWR sky130_fd_sc_hd__fill_1
XFILLER_0_1_193 VPWR VGND VPWR VGND sky130_ef_sc_hd__decap_12
XFILLER_0_96_1225 VGND VGND VPWR VPWR sky130_fd_sc_hd__fill_1
XANTENNA_input1_A act_row0_in[0] VGND VGND VPWR VPWR sky130_fd_sc_hd__diode_2
XFILLER_0_222_581 VGND VGND VPWR VPWR sky130_fd_sc_hd__decap_6
XFILLER_0_215_27 VPWR VGND VPWR VGND sky130_ef_sc_hd__decap_12
XFILLER_0_136_1281 VGND VGND VPWR VPWR sky130_fd_sc_hd__fill_1
XFILLER_0_167_647 VGND VGND VPWR VPWR sky130_fd_sc_hd__decap_8
XPHY_902 VGND VGND VPWR VPWR sky130_fd_sc_hd__decap_3
XPHY_924 VGND VGND VPWR VPWR sky130_fd_sc_hd__decap_3
XPHY_913 VGND VGND VPWR VPWR sky130_fd_sc_hd__decap_3
XPHY_935 VGND VGND VPWR VPWR sky130_fd_sc_hd__decap_3
XFILLER_0_33_1253 VGND VGND VPWR VPWR sky130_fd_sc_hd__fill_1
XPHY_979 VGND VGND VPWR VPWR sky130_fd_sc_hd__decap_3
XFILLER_0_182_617 VGND VGND VPWR VPWR sky130_fd_sc_hd__fill_1
XPHY_946 VGND VGND VPWR VPWR sky130_fd_sc_hd__decap_3
XFILLER_0_108_725 VPWR VGND VPWR VGND sky130_ef_sc_hd__decap_12
XFILLER_0_65_645 VGND VGND VPWR VPWR sky130_fd_sc_hd__fill_1
XPHY_957 VGND VGND VPWR VPWR sky130_fd_sc_hd__decap_3
XPHY_968 VGND VGND VPWR VPWR sky130_fd_sc_hd__decap_3
XFILLER_0_108_769 VPWR VGND VPWR VGND sky130_ef_sc_hd__decap_12
XFILLER_0_208_1227 VPWR VGND VPWR VGND sky130_ef_sc_hd__decap_12
XFILLER_0_107_279 VGND VGND VPWR VPWR sky130_fd_sc_hd__fill_1
XFILLER_0_104_953 VPWR VGND VPWR VGND sky130_ef_sc_hd__decap_12
XANTENNA_input57_A psum_col0_in[30] VGND VGND VPWR VPWR sky130_fd_sc_hd__diode_2
XFILLER_0_40_1213 VPWR VGND VPWR VGND sky130_ef_sc_hd__decap_12
XFILLER_0_178_1337 VGND VGND VPWR VPWR sky130_fd_sc_hd__fill_1
XFILLER_0_18_15 VPWR VGND VPWR VGND sky130_ef_sc_hd__decap_12
XFILLER_0_109_39 VPWR VGND VPWR VGND sky130_ef_sc_hd__decap_12
XFILLER_0_219_1301 VPWR VGND VPWR VGND sky130_ef_sc_hd__decap_12
XFILLER_0_75_1309 VGND VGND VPWR VPWR sky130_fd_sc_hd__fill_1
XANTENNA_output213_A net213 VGND VGND VPWR VPWR sky130_fd_sc_hd__diode_2
XFILLER_0_125_27 VPWR VGND VPWR VGND sky130_ef_sc_hd__decap_12
XFILLER_0_150_1201 VPWR VGND VPWR VGND sky130_ef_sc_hd__decap_12
XFILLER_0_115_1343 VGND VGND VPWR VPWR sky130_fd_sc_hd__fill_1
XTAP_2350 VGND VPWR sky130_fd_sc_hd__tapvpwrvgnd_1
XTAP_2361 VGND VPWR sky130_fd_sc_hd__tapvpwrvgnd_1
XTAP_2383 VGND VPWR sky130_fd_sc_hd__tapvpwrvgnd_1
XTAP_2394 VGND VPWR sky130_fd_sc_hd__tapvpwrvgnd_1
XTAP_2372 VGND VPWR sky130_fd_sc_hd__tapvpwrvgnd_1
XTAP_1660 VGND VPWR sky130_fd_sc_hd__tapvpwrvgnd_1
XFILLER_0_173_617 VPWR VGND VPWR VGND sky130_ef_sc_hd__decap_12
XTAP_1693 VGND VPWR sky130_fd_sc_hd__tapvpwrvgnd_1
XTAP_1682 VGND VPWR sky130_fd_sc_hd__tapvpwrvgnd_1
XFILLER_0_12_1337 VGND VGND VPWR VPWR sky130_fd_sc_hd__fill_1
XTAP_1671 VGND VPWR sky130_fd_sc_hd__tapvpwrvgnd_1
XFILLER_0_133_6 VGND VGND VPWR VPWR sky130_fd_sc_hd__fill_2
XFILLER_0_141_15 VPWR VGND VPWR VGND sky130_ef_sc_hd__decap_12
XFILLER_0_226_1305 VGND VGND VPWR VPWR sky130_fd_sc_hd__decap_8
XFILLER_0_226_1327 VGND VGND VPWR VPWR sky130_fd_sc_hd__decap_8
XFILLER_0_221_81 VPWR VGND VPWR VGND sky130_ef_sc_hd__decap_12
XFILLER_0_4_937 VPWR VGND VPWR VGND sky130_ef_sc_hd__decap_12
XFILLER_0_113_205 VPWR VGND VPWR VGND sky130_ef_sc_hd__decap_12
XFILLER_0_109_1169 VGND VGND VPWR VPWR sky130_fd_sc_hd__decap_6
XFILLER_0_3_447 VGND VGND VPWR VPWR sky130_fd_sc_hd__fill_1
XFILLER_0_113_249 VPWR VGND VPWR VGND sky130_ef_sc_hd__decap_12
XFILLER_0_224_1073 VPWR VGND VPWR VGND sky130_ef_sc_hd__decap_12
XFILLER_0_110_923 VGND VGND VPWR VPWR sky130_fd_sc_hd__fill_1
XANTENNA_u_pe00_act_in[3] net10 VGND VGND VPWR VPWR sky130_fd_sc_hd__diode_2
XFILLER_0_224_813 VPWR VGND VPWR VGND sky130_ef_sc_hd__decap_12
XFILLER_0_211_529 VPWR VGND VPWR VGND sky130_ef_sc_hd__decap_12
XFILLER_0_95_1291 VPWR VGND VPWR VGND sky130_ef_sc_hd__decap_12
XFILLER_0_149_647 VGND VGND VPWR VPWR sky130_fd_sc_hd__decap_8
XFILLER_0_17_1237 VPWR VGND VPWR VGND sky130_ef_sc_hd__decap_12
XFILLER_0_56_1275 VGND VGND VPWR VPWR sky130_fd_sc_hd__decap_6
XPHY_209 VGND VGND VPWR VPWR sky130_fd_sc_hd__decap_3
XFILLER_0_164_617 VGND VGND VPWR VPWR sky130_fd_sc_hd__fill_1
XFILLER_0_47_645 VGND VGND VPWR VPWR sky130_fd_sc_hd__fill_1
XFILLER_0_7_753 VGND VGND VPWR VPWR sky130_fd_sc_hd__decap_3
XFILLER_0_166_1263 VPWR VGND VPWR VGND sky130_ef_sc_hd__decap_12
XFILLER_0_127_1225 VPWR VGND VPWR VGND sky130_ef_sc_hd__decap_12
XFILLER_0_7_797 VPWR VGND VPWR VGND sky130_ef_sc_hd__decap_12
XFILLER_0_63_1213 VPWR VGND VPWR VGND sky130_ef_sc_hd__decap_12
XFILLER_0_104_249 VGND VGND VPWR VPWR sky130_fd_sc_hd__decap_3
XFILLER_0_113_783 VGND VGND VPWR VPWR sky130_fd_sc_hd__fill_1
XFILLER_0_219_629 VPWR VGND VPWR VGND sky130_ef_sc_hd__decap_12
XFILLER_0_63_1279 VPWR VGND VPWR VGND sky130_ef_sc_hd__decap_12
XFILLER_0_218_139 VGND VGND VPWR VPWR sky130_fd_sc_hd__fill_1
XFILLER_0_214_301 VGND VGND VPWR VPWR sky130_fd_sc_hd__decap_6
XFILLER_0_173_1201 VPWR VGND VPWR VGND sky130_ef_sc_hd__decap_12
XFILLER_0_103_1291 VPWR VGND VPWR VGND sky130_ef_sc_hd__decap_12
XFILLER_0_226_194 VGND VGND VPWR VPWR sky130_fd_sc_hd__fill_2
XFILLER_0_214_345 VPWR VGND VPWR VGND sky130_ef_sc_hd__decap_12
XFILLER_0_138_1343 VGND VGND VPWR VPWR sky130_fd_sc_hd__fill_1
XFILLER_0_214_389 VPWR VGND VPWR VGND sky130_ef_sc_hd__decap_12
XFILLER_0_173_1267 VPWR VGND VPWR VGND sky130_ef_sc_hd__decap_12
XFILLER_0_74_1331 VGND VGND VPWR VPWR sky130_fd_sc_hd__decap_6
XANTENNA_input111_A w00[4] VGND VGND VPWR VPWR sky130_fd_sc_hd__diode_2
XFILLER_0_214_1253 VGND VGND VPWR VPWR sky130_fd_sc_hd__decap_6
XFILLER_0_210_1117 VGND VGND VPWR VPWR sky130_fd_sc_hd__fill_1
XFILLER_0_210_573 VPWR VGND VPWR VGND sky130_ef_sc_hd__decap_12
XFILLER_0_70_1239 VPWR VGND VPWR VGND sky130_ef_sc_hd__decap_12
XPHY_710 VGND VGND VPWR VPWR sky130_fd_sc_hd__decap_3
XFILLER_0_214_1297 VPWR VGND VPWR VGND sky130_ef_sc_hd__decap_12
XPHY_732 VGND VGND VPWR VPWR sky130_fd_sc_hd__decap_3
XPHY_721 VGND VGND VPWR VPWR sky130_fd_sc_hd__decap_3
XFILLER_0_155_617 VPWR VGND VPWR VGND sky130_ef_sc_hd__decap_12
XPHY_754 VGND VGND VPWR VPWR sky130_fd_sc_hd__decap_3
XPHY_743 VGND VGND VPWR VPWR sky130_fd_sc_hd__decap_3
XPHY_787 VGND VGND VPWR VPWR sky130_fd_sc_hd__decap_3
XFILLER_0_108_533 VPWR VGND VPWR VGND sky130_ef_sc_hd__decap_12
XPHY_776 VGND VGND VPWR VPWR sky130_fd_sc_hd__decap_3
XPHY_765 VGND VGND VPWR VPWR sky130_fd_sc_hd__decap_3
XPHY_798 VGND VGND VPWR VPWR sky130_fd_sc_hd__decap_3
XFILLER_0_110_1273 VPWR VGND VPWR VGND sky130_ef_sc_hd__decap_12
XFILLER_0_145_1303 VGND VGND VPWR VPWR sky130_fd_sc_hd__decap_6
XFILLER_0_20_49 VGND VGND VPWR VPWR sky130_fd_sc_hd__fill_1
XFILLER_0_20_27 VGND VGND VPWR VPWR sky130_fd_sc_hd__fill_1
XFILLER_0_180_1227 VPWR VGND VPWR VGND sky130_ef_sc_hd__decap_12
XFILLER_0_106_1309 VGND VGND VPWR VPWR sky130_fd_sc_hd__decap_6
XFILLER_0_111_709 VPWR VGND VPWR VGND sky130_ef_sc_hd__decap_12
XFILLER_0_221_1213 VPWR VGND VPWR VGND sky130_ef_sc_hd__decap_12
XFILLER_0_0_417 VGND VGND VPWR VPWR sky130_fd_sc_hd__decap_3
XFILLER_0_81_1335 VGND VGND VPWR VPWR sky130_fd_sc_hd__decap_8
XFILLER_0_104_1033 VGND VGND VPWR VPWR sky130_fd_sc_hd__decap_3
XFILLER_0_0_439 VGND VGND VPWR VPWR sky130_fd_sc_hd__decap_8
XFILLER_0_42_1319 VPWR VGND VPWR VGND sky130_ef_sc_hd__decap_12
XFILLER_0_221_1257 VPWR VGND VPWR VGND sky130_ef_sc_hd__decap_12
XFILLER_0_29_47 VGND VGND VPWR VPWR sky130_fd_sc_hd__fill_1
XFILLER_0_224_109 VPWR VGND VPWR VGND sky130_ef_sc_hd__decap_12
XFILLER_0_104_1077 VPWR VGND VPWR VGND sky130_ef_sc_hd__decap_12
XFILLER_0_217_161 VGND VGND VPWR VPWR sky130_fd_sc_hd__decap_6
XFILLER_0_45_13 VPWR VGND VPWR VGND sky130_ef_sc_hd__decap_12
XFILLER_0_79_1253 VGND VGND VPWR VPWR sky130_fd_sc_hd__fill_1
XFILLER_0_191_1323 VGND VGND VPWR VPWR sky130_fd_sc_hd__decap_8
XFILLER_0_219_1175 VGND VGND VPWR VPWR sky130_fd_sc_hd__fill_1
XFILLER_0_152_1307 VPWR VGND VPWR VGND sky130_ef_sc_hd__decap_12
XFILLER_0_0_15 VPWR VGND VPWR VGND sky130_ef_sc_hd__decap_12
XTAP_2180 VGND VPWR sky130_fd_sc_hd__tapvpwrvgnd_1
XFILLER_0_5_1213 VPWR VGND VPWR VGND sky130_ef_sc_hd__decap_12
XTAP_2191 VGND VPWR sky130_fd_sc_hd__tapvpwrvgnd_1
XFILLER_0_146_617 VGND VGND VPWR VPWR sky130_fd_sc_hd__fill_1
XFILLER_0_29_645 VGND VGND VPWR VPWR sky130_fd_sc_hd__fill_1
XFILLER_0_5_1257 VPWR VGND VPWR VGND sky130_ef_sc_hd__decap_12
XFILLER_0_131_3 VPWR VGND VPWR VGND sky130_ef_sc_hd__decap_12
XTAP_1490 VGND VPWR sky130_fd_sc_hd__tapvpwrvgnd_1
XFILLER_0_16_1281 VGND VGND VPWR VPWR sky130_fd_sc_hd__fill_1
XFILLER_0_4_701 VPWR VGND VPWR VGND sky130_ef_sc_hd__decap_12
XFILLER_0_86_1213 VPWR VGND VPWR VGND sky130_ef_sc_hd__decap_12
XFILLER_0_226_1135 VGND VGND VPWR VPWR sky130_fd_sc_hd__decap_8
XFILLER_0_200_1319 VPWR VGND VPWR VGND sky130_ef_sc_hd__decap_12
XFILLER_0_196_1201 VPWR VGND VPWR VGND sky130_ef_sc_hd__decap_12
XFILLER_0_0_951 VGND VGND VPWR VPWR sky130_fd_sc_hd__fill_1
XFILLER_0_36_3 VPWR VGND VPWR VGND sky130_ef_sc_hd__decap_12
XFILLER_0_224_643 VGND VGND VPWR VPWR sky130_fd_sc_hd__fill_1
XFILLER_0_212_805 VGND VGND VPWR VPWR sky130_fd_sc_hd__decap_6
XFILLER_0_58_1337 VGND VGND VPWR VPWR sky130_fd_sc_hd__fill_1
XFILLER_0_212_849 VPWR VGND VPWR VGND sky130_ef_sc_hd__decap_12
XFILLER_0_211_337 VPWR VGND VPWR VGND sky130_ef_sc_hd__decap_12
XFILLER_0_220_893 VPWR VGND VPWR VGND sky130_ef_sc_hd__decap_12
XFILLER_0_137_617 VPWR VGND VPWR VGND sky130_ef_sc_hd__decap_12
XFILLER_0_30_1201 VPWR VGND VPWR VGND sky130_ef_sc_hd__decap_12
XFILLER_0_129_1309 VGND VGND VPWR VPWR sky130_fd_sc_hd__fill_1
XFILLER_0_209_1311 VPWR VGND VPWR VGND sky130_ef_sc_hd__decap_12
XFILLER_0_105_503 VGND VGND VPWR VPWR sky130_fd_sc_hd__fill_1
XFILLER_0_7_561 VPWR VGND VPWR VGND sky130_ef_sc_hd__decap_12
XFILLER_0_160_631 VPWR VGND VPWR VGND sky130_ef_sc_hd__decap_12
XANTENNA_input159_A w11[4] VGND VGND VPWR VPWR sky130_fd_sc_hd__diode_2
XFILLER_0_215_665 VGND VGND VPWR VPWR sky130_fd_sc_hd__decap_6
XFILLER_0_216_1315 VGND VGND VPWR VPWR sky130_fd_sc_hd__fill_1
XFILLER_0_214_153 VPWR VGND VPWR VGND sky130_ef_sc_hd__decap_12
XFILLER_0_214_197 VPWR VGND VPWR VGND sky130_ef_sc_hd__decap_12
XFILLER_0_15_27 VPWR VGND VPWR VGND sky130_ef_sc_hd__decap_12
XFILLER_0_106_29 VPWR VGND VPWR VGND sky130_ef_sc_hd__decap_12
XFILLER_0_214_1061 VPWR VGND VPWR VGND sky130_ef_sc_hd__decap_12
XFILLER_0_128_617 VGND VGND VPWR VPWR sky130_fd_sc_hd__fill_1
XPHY_540 VGND VGND VPWR VPWR sky130_fd_sc_hd__decap_3
XPHY_551 VGND VGND VPWR VPWR sky130_fd_sc_hd__decap_3
XPHY_562 VGND VGND VPWR VPWR sky130_fd_sc_hd__decap_3
XPHY_1150 VGND VGND VPWR VPWR sky130_fd_sc_hd__decap_3
XPHY_595 VGND VGND VPWR VPWR sky130_fd_sc_hd__decap_3
XPHY_584 VGND VGND VPWR VPWR sky130_fd_sc_hd__decap_3
XPHY_573 VGND VGND VPWR VPWR sky130_fd_sc_hd__decap_3
XFILLER_0_109_853 VPWR VGND VPWR VGND sky130_ef_sc_hd__decap_12
XFILLER_0_31_37 VGND VGND VPWR VPWR sky130_fd_sc_hd__decap_8
XFILLER_0_0_1121 VGND VGND VPWR VPWR sky130_fd_sc_hd__fill_2
XPHY_1183 VGND VGND VPWR VPWR sky130_fd_sc_hd__decap_3
XPHY_1172 VGND VGND VPWR VPWR sky130_fd_sc_hd__decap_3
XPHY_1161 VGND VGND VPWR VPWR sky130_fd_sc_hd__decap_3
XFILLER_0_109_897 VPWR VGND VPWR VGND sky130_ef_sc_hd__decap_12
XFILLER_0_0_1143 VGND VGND VPWR VPWR sky130_fd_sc_hd__decap_3
XFILLER_0_108_363 VGND VGND VPWR VPWR sky130_fd_sc_hd__fill_1
XPHY_1194 VGND VGND VPWR VPWR sky130_fd_sc_hd__decap_3
XFILLER_0_149_1291 VPWR VGND VPWR VGND sky130_ef_sc_hd__decap_12
XFILLER_0_41_629 VPWR VGND VPWR VGND sky130_ef_sc_hd__decap_12
XFILLER_0_106_1117 VPWR VGND VPWR VGND sky130_ef_sc_hd__decap_12
XFILLER_0_111_517 VPWR VGND VPWR VGND sky130_ef_sc_hd__decap_12
XFILLER_0_221_1021 VPWR VGND VPWR VGND sky130_ef_sc_hd__decap_12
XFILLER_0_46_1263 VPWR VGND VPWR VGND sky130_ef_sc_hd__decap_12
XFILLER_0_221_1065 VPWR VGND VPWR VGND sky130_ef_sc_hd__decap_12
XFILLER_0_226_908 VPWR VGND VPWR VGND sky130_ef_sc_hd__decap_12
XFILLER_0_225_429 VPWR VGND VPWR VGND sky130_ef_sc_hd__decap_12
XFILLER_0_206_643 VPWR VGND VPWR VGND sky130_ef_sc_hd__decap_12
XFILLER_0_179_3 VPWR VGND VPWR VGND sky130_ef_sc_hd__decap_12
XFILLER_0_156_1251 VPWR VGND VPWR VGND sky130_ef_sc_hd__decap_12
XFILLER_0_117_1213 VPWR VGND VPWR VGND sky130_ef_sc_hd__decap_12
XFILLER_0_156_1295 VPWR VGND VPWR VGND sky130_ef_sc_hd__decap_12
XFILLER_0_53_1201 VPWR VGND VPWR VGND sky130_ef_sc_hd__decap_12
XFILLER_0_117_1279 VPWR VGND VPWR VGND sky130_ef_sc_hd__decap_12
XFILLER_0_92_1283 VPWR VGND VPWR VGND sky130_ef_sc_hd__decap_12
XFILLER_0_18_1343 VGND VGND VPWR VPWR sky130_fd_sc_hd__fill_1
XFILLER_0_220_189 VGND VGND VPWR VPWR sky130_fd_sc_hd__decap_6
XFILLER_0_119_617 VPWR VGND VPWR VGND sky130_ef_sc_hd__decap_12
XFILLER_0_5_1021 VPWR VGND VPWR VGND sky130_ef_sc_hd__decap_12
XFILLER_0_53_1267 VPWR VGND VPWR VGND sky130_ef_sc_hd__decap_12
XFILLER_0_88_1319 VPWR VGND VPWR VGND sky130_ef_sc_hd__decap_12
XFILLER_0_5_1065 VPWR VGND VPWR VGND sky130_ef_sc_hd__decap_12
XFILLER_0_128_1331 VGND VGND VPWR VPWR sky130_fd_sc_hd__decap_6
XFILLER_0_142_631 VPWR VGND VPWR VGND sky130_ef_sc_hd__decap_12
XFILLER_0_4_531 VGND VGND VPWR VPWR sky130_fd_sc_hd__fill_1
XFILLER_0_112_83 VGND VGND VPWR VPWR sky130_fd_sc_hd__fill_1
XFILLER_0_114_333 VGND VGND VPWR VPWR sky130_fd_sc_hd__decap_3
XFILLER_0_163_1255 VPWR VGND VPWR VGND sky130_ef_sc_hd__decap_12
XFILLER_0_114_377 VPWR VGND VPWR VGND sky130_ef_sc_hd__decap_12
XFILLER_0_124_1239 VPWR VGND VPWR VGND sky130_ef_sc_hd__decap_12
XFILLER_0_25_1303 VGND VGND VPWR VPWR sky130_fd_sc_hd__decap_6
XFILLER_0_204_1263 VPWR VGND VPWR VGND sky130_ef_sc_hd__decap_12
XFILLER_0_198_1307 VPWR VGND VPWR VGND sky130_ef_sc_hd__decap_12
XFILLER_0_60_1227 VPWR VGND VPWR VGND sky130_ef_sc_hd__decap_12
XFILLER_0_99_629 VPWR VGND VPWR VGND sky130_ef_sc_hd__decap_12
XFILLER_0_212_613 VPWR VGND VPWR VGND sky130_ef_sc_hd__decap_12
XFILLER_0_207_39 VGND VGND VPWR VPWR sky130_fd_sc_hd__decap_8
XFILLER_0_100_1283 VPWR VGND VPWR VGND sky130_ef_sc_hd__decap_12
XTAP_2916 VGND VPWR sky130_fd_sc_hd__tapvpwrvgnd_1
XTAP_2905 VGND VPWR sky130_fd_sc_hd__tapvpwrvgnd_1
XFILLER_0_212_657 VPWR VGND VPWR VGND sky130_ef_sc_hd__decap_12
XTAP_2927 VGND VPWR sky130_fd_sc_hd__tapvpwrvgnd_1
XFILLER_0_135_1335 VGND VGND VPWR VPWR sky130_fd_sc_hd__decap_8
XTAP_2949 VGND VPWR sky130_fd_sc_hd__tapvpwrvgnd_1
XTAP_2938 VGND VPWR sky130_fd_sc_hd__tapvpwrvgnd_1
XFILLER_0_211_167 VGND VGND VPWR VPWR sky130_fd_sc_hd__fill_1
XFILLER_0_71_1323 VPWR VGND VPWR VGND sky130_ef_sc_hd__decap_12
XFILLER_0_211_1201 VPWR VGND VPWR VGND sky130_ef_sc_hd__decap_12
XFILLER_0_223_27 VPWR VGND VPWR VGND sky130_ef_sc_hd__decap_12
XFILLER_0_32_1307 VPWR VGND VPWR VGND sky130_ef_sc_hd__decap_12
XFILLER_0_211_1245 VPWR VGND VPWR VGND sky130_ef_sc_hd__decap_12
XFILLER_0_109_105 VGND VGND VPWR VPWR sky130_fd_sc_hd__decap_6
XFILLER_0_211_1289 VPWR VGND VPWR VGND sky130_ef_sc_hd__decap_12
XFILLER_0_109_149 VPWR VGND VPWR VGND sky130_ef_sc_hd__decap_12
XFILLER_0_181_1311 VPWR VGND VPWR VGND sky130_ef_sc_hd__decap_12
XFILLER_0_106_867 VGND VGND VPWR VPWR sky130_fd_sc_hd__fill_1
XFILLER_0_23_629 VPWR VGND VPWR VGND sky130_ef_sc_hd__decap_12
XFILLER_0_142_1339 VGND VGND VPWR VPWR sky130_fd_sc_hd__decap_4
XFILLER_0_222_1341 VGND VGND VPWR VPWR sky130_fd_sc_hd__decap_3
XFILLER_0_219_223 VGND VGND VPWR VPWR sky130_fd_sc_hd__fill_1
XFILLER_0_26_15 VPWR VGND VPWR VGND sky130_ef_sc_hd__decap_12
XFILLER_0_76_1201 VPWR VGND VPWR VGND sky130_ef_sc_hd__decap_12
XFILLER_0_215_473 VPWR VGND VPWR VGND sky130_ef_sc_hd__decap_12
XFILLER_0_117_39 VGND VGND VPWR VPWR sky130_fd_sc_hd__decap_8
XFILLER_0_42_25 VGND VGND VPWR VPWR sky130_fd_sc_hd__decap_3
XFILLER_0_6_1341 VGND VGND VPWR VPWR sky130_fd_sc_hd__decap_3
XFILLER_0_2_1205 VPWR VGND VPWR VGND sky130_ef_sc_hd__decap_12
XPHY_370 VGND VGND VPWR VPWR sky130_fd_sc_hd__decap_3
XANTENNA_u_pe10_clk clknet_1_0__leaf_clk VGND VGND VPWR VPWR sky130_fd_sc_hd__diode_2
XFILLER_0_213_93 VPWR VGND VPWR VGND sky130_ef_sc_hd__decap_12
XFILLER_0_5_317 VPWR VGND VPWR VGND sky130_ef_sc_hd__decap_12
XPHY_381 VGND VGND VPWR VPWR sky130_fd_sc_hd__decap_3
XPHY_392 VGND VGND VPWR VPWR sky130_fd_sc_hd__decap_3
XFILLER_0_124_631 VPWR VGND VPWR VGND sky130_ef_sc_hd__decap_12
XFILLER_0_83_1249 VGND VGND VPWR VPWR sky130_fd_sc_hd__decap_4
XFILLER_0_112_837 VPWR VGND VPWR VGND sky130_ef_sc_hd__decap_12
XFILLER_0_225_237 VPWR VGND VPWR VGND sky130_ef_sc_hd__decap_12
XFILLER_0_193_1237 VPWR VGND VPWR VGND sky130_ef_sc_hd__decap_12
XPHY_29 VGND VGND VPWR VPWR sky130_fd_sc_hd__decap_3
XPHY_18 VGND VGND VPWR VPWR sky130_fd_sc_hd__decap_3
XFILLER_0_7_1105 VPWR VGND VPWR VGND sky130_ef_sc_hd__decap_12
XFILLER_0_7_1149 VPWR VGND VPWR VGND sky130_ef_sc_hd__decap_12
XANTENNA_u_pe01_clk clknet_1_1__leaf_clk VGND VGND VPWR VPWR sky130_fd_sc_hd__diode_2
XFILLER_0_107_609 VGND VGND VPWR VPWR sky130_fd_sc_hd__decap_6
XFILLER_0_9_645 VGND VGND VPWR VPWR sky130_fd_sc_hd__fill_1
XFILLER_0_114_141 VPWR VGND VPWR VGND sky130_ef_sc_hd__decap_12
XFILLER_0_5_895 VGND VGND VPWR VPWR sky130_fd_sc_hd__fill_1
XFILLER_0_29_1291 VPWR VGND VPWR VGND sky130_ef_sc_hd__decap_12
XFILLER_0_99_1201 VPWR VGND VPWR VGND sky130_ef_sc_hd__decap_12
XFILLER_0_217_727 VGND VGND VPWR VPWR sky130_fd_sc_hd__fill_1
XFILLER_0_218_27 VGND VGND VPWR VPWR sky130_fd_sc_hd__fill_1
XFILLER_0_99_1267 VPWR VGND VPWR VGND sky130_ef_sc_hd__decap_12
XTAP_2702 VGND VPWR sky130_fd_sc_hd__tapvpwrvgnd_1
XFILLER_0_213_933 VPWR VGND VPWR VGND sky130_ef_sc_hd__decap_12
XFILLER_0_212_421 VPWR VGND VPWR VGND sky130_ef_sc_hd__decap_12
XTAP_2724 VGND VPWR sky130_fd_sc_hd__tapvpwrvgnd_1
XTAP_2746 VGND VPWR sky130_fd_sc_hd__tapvpwrvgnd_1
XFILLER_0_213_977 VPWR VGND VPWR VGND sky130_ef_sc_hd__decap_12
XFILLER_0_200_605 VPWR VGND VPWR VGND sky130_ef_sc_hd__decap_12
XFILLER_0_197_645 VGND VGND VPWR VPWR sky130_fd_sc_hd__fill_1
XTAP_2713 VGND VPWR sky130_fd_sc_hd__tapvpwrvgnd_1
XTAP_2735 VGND VPWR sky130_fd_sc_hd__tapvpwrvgnd_1
XTAP_2768 VGND VPWR sky130_fd_sc_hd__tapvpwrvgnd_1
XTAP_2757 VGND VPWR sky130_fd_sc_hd__tapvpwrvgnd_1
XTAP_2779 VGND VPWR sky130_fd_sc_hd__tapvpwrvgnd_1
XFILLER_0_36_1251 VPWR VGND VPWR VGND sky130_ef_sc_hd__decap_12
XFILLER_0_36_1295 VPWR VGND VPWR VGND sky130_ef_sc_hd__decap_12
XANTENNA_input87_A psum_col1_in[29] VGND VGND VPWR VPWR sky130_fd_sc_hd__diode_2
XFILLER_0_107_1201 VPWR VGND VPWR VGND sky130_ef_sc_hd__decap_12
XFILLER_0_2_309 VPWR VGND VPWR VGND sky130_ef_sc_hd__decap_12
XFILLER_0_146_1283 VPWR VGND VPWR VGND sky130_ef_sc_hd__decap_12
XFILLER_0_107_1245 VPWR VGND VPWR VGND sky130_ef_sc_hd__decap_12
XFILLER_0_121_645 VGND VGND VPWR VPWR sky130_fd_sc_hd__fill_1
XFILLER_0_107_1289 VPWR VGND VPWR VGND sky130_ef_sc_hd__decap_12
XFILLER_0_43_1255 VPWR VGND VPWR VGND sky130_ef_sc_hd__decap_12
XFILLER_0_78_1307 VPWR VGND VPWR VGND sky130_ef_sc_hd__decap_12
XFILLER_0_128_27 VGND VGND VPWR VPWR sky130_fd_sc_hd__fill_1
XFILLER_0_37_47 VGND VGND VPWR VPWR sky130_fd_sc_hd__fill_1
XFILLER_0_128_49 VGND VGND VPWR VPWR sky130_fd_sc_hd__fill_1
XFILLER_0_218_1229 VPWR VGND VPWR VGND sky130_ef_sc_hd__decap_12
Xinput150 w11[10] VGND VGND VPWR VPWR net150 sky130_fd_sc_hd__clkbuf_8
Xinput161 w11[6] VGND VGND VPWR VPWR net161 sky130_fd_sc_hd__buf_4
XFILLER_0_216_793 VPWR VGND VPWR VGND sky130_ef_sc_hd__decap_12
XFILLER_0_215_281 VPWR VGND VPWR VGND sky130_ef_sc_hd__decap_12
XFILLER_0_144_15 VPWR VGND VPWR VGND sky130_ef_sc_hd__decap_12
XFILLER_0_192_1281 VGND VGND VPWR VPWR sky130_fd_sc_hd__fill_1
XFILLER_0_114_1205 VPWR VGND VPWR VGND sky130_ef_sc_hd__decap_12
XFILLER_0_86_643 VPWR VGND VPWR VGND sky130_ef_sc_hd__decap_12
XFILLER_0_15_1335 VGND VGND VPWR VPWR sky130_fd_sc_hd__decap_8
XFILLER_0_188_1339 VGND VGND VPWR VPWR sky130_fd_sc_hd__decap_4
XFILLER_0_2_1035 VGND VGND VPWR VPWR sky130_fd_sc_hd__fill_1
XFILLER_0_211_3 VPWR VGND VPWR VGND sky130_ef_sc_hd__decap_12
XFILLER_0_5_125 VPWR VGND VPWR VGND sky130_ef_sc_hd__decap_12
XFILLER_0_6_637 VGND VGND VPWR VPWR sky130_fd_sc_hd__decap_6
XFILLER_0_112_601 VPWR VGND VPWR VGND sky130_ef_sc_hd__decap_12
XFILLER_0_5_169 VPWR VGND VPWR VGND sky130_ef_sc_hd__decap_12
XFILLER_0_125_1323 VPWR VGND VPWR VGND sky130_ef_sc_hd__decap_12
XFILLER_0_111_111 VGND VGND VPWR VPWR sky130_fd_sc_hd__fill_1
XFILLER_0_160_1225 VGND VGND VPWR VPWR sky130_fd_sc_hd__fill_1
XFILLER_0_112_645 VPWR VGND VPWR VGND sky130_ef_sc_hd__decap_12
XFILLER_0_61_1311 VPWR VGND VPWR VGND sky130_ef_sc_hd__decap_12
XFILLER_0_10_643 VPWR VGND VPWR VGND sky130_ef_sc_hd__decap_12
XFILLER_0_201_1255 VPWR VGND VPWR VGND sky130_ef_sc_hd__decap_12
XFILLER_0_226_524 VGND VGND VPWR VPWR sky130_fd_sc_hd__decap_8
XFILLER_0_226_502 VGND VGND VPWR VPWR sky130_fd_sc_hd__fill_2
XFILLER_0_22_1339 VGND VGND VPWR VPWR sky130_fd_sc_hd__decap_4
XFILLER_0_179_645 VGND VGND VPWR VPWR sky130_fd_sc_hd__fill_1
XTAP_2009 VGND VPWR sky130_fd_sc_hd__tapvpwrvgnd_1
XFILLER_0_210_925 VGND VGND VPWR VPWR sky130_fd_sc_hd__fill_2
XFILLER_0_221_273 VGND VGND VPWR VPWR sky130_fd_sc_hd__decap_6
XFILLER_0_171_1343 VGND VGND VPWR VPWR sky130_fd_sc_hd__fill_1
XTAP_1319 VGND VPWR sky130_fd_sc_hd__tapvpwrvgnd_1
XTAP_1308 VGND VPWR sky130_fd_sc_hd__tapvpwrvgnd_1
XFILLER_0_204_29 VPWR VGND VPWR VGND sky130_ef_sc_hd__decap_12
XFILLER_0_107_417 VPWR VGND VPWR VGND sky130_ef_sc_hd__decap_12
XFILLER_0_103_645 VGND VGND VPWR VPWR sky130_fd_sc_hd__fill_1
XANTENNA_input141_A w10[2] VGND VGND VPWR VPWR sky130_fd_sc_hd__diode_2
XFILLER_0_213_741 VPWR VGND VPWR VGND sky130_ef_sc_hd__decap_12
XTAP_2510 VGND VPWR sky130_fd_sc_hd__tapvpwrvgnd_1
XFILLER_0_137_1249 VGND VGND VPWR VPWR sky130_fd_sc_hd__decap_4
XFILLER_0_73_1237 VPWR VGND VPWR VGND sky130_ef_sc_hd__decap_12
XFILLER_0_213_785 VPWR VGND VPWR VGND sky130_ef_sc_hd__decap_12
XTAP_2554 VGND VPWR sky130_fd_sc_hd__tapvpwrvgnd_1
XTAP_2543 VGND VPWR sky130_fd_sc_hd__tapvpwrvgnd_1
XTAP_2532 VGND VPWR sky130_fd_sc_hd__tapvpwrvgnd_1
XFILLER_0_212_251 VGND VGND VPWR VPWR sky130_fd_sc_hd__fill_1
XTAP_2521 VGND VPWR sky130_fd_sc_hd__tapvpwrvgnd_1
XTAP_2565 VGND VPWR sky130_fd_sc_hd__tapvpwrvgnd_1
XTAP_2587 VGND VPWR sky130_fd_sc_hd__tapvpwrvgnd_1
XTAP_2576 VGND VPWR sky130_fd_sc_hd__tapvpwrvgnd_1
XTAP_1831 VGND VPWR sky130_fd_sc_hd__tapvpwrvgnd_1
XTAP_1820 VGND VPWR sky130_fd_sc_hd__tapvpwrvgnd_1
XFILLER_0_23_27 VPWR VGND VPWR VGND sky130_ef_sc_hd__decap_12
XFILLER_0_68_643 VPWR VGND VPWR VGND sky130_ef_sc_hd__decap_12
XTAP_1842 VGND VPWR sky130_fd_sc_hd__tapvpwrvgnd_1
XFILLER_0_114_29 VPWR VGND VPWR VGND sky130_ef_sc_hd__decap_12
XTAP_2598 VGND VPWR sky130_fd_sc_hd__tapvpwrvgnd_1
XTAP_1875 VGND VPWR sky130_fd_sc_hd__tapvpwrvgnd_1
XTAP_1864 VGND VPWR sky130_fd_sc_hd__tapvpwrvgnd_1
XTAP_1853 VGND VPWR sky130_fd_sc_hd__tapvpwrvgnd_1
XTAP_1897 VGND VPWR sky130_fd_sc_hd__tapvpwrvgnd_1
XTAP_1886 VGND VPWR sky130_fd_sc_hd__tapvpwrvgnd_1
XFILLER_0_183_1225 VPWR VGND VPWR VGND sky130_ef_sc_hd__decap_12
XFILLER_0_107_951 VGND VGND VPWR VPWR sky130_fd_sc_hd__fill_1
XFILLER_0_3_629 VPWR VGND VPWR VGND sky130_ef_sc_hd__decap_12
XFILLER_0_2_139 VGND VGND VPWR VPWR sky130_fd_sc_hd__fill_1
XFILLER_0_139_15 VPWR VGND VPWR VGND sky130_ef_sc_hd__decap_12
XFILLER_0_194_1343 VGND VGND VPWR VPWR sky130_fd_sc_hd__fill_1
XFILLER_0_223_505 VPWR VGND VPWR VGND sky130_ef_sc_hd__decap_12
XFILLER_0_219_81 VPWR VGND VPWR VGND sky130_ef_sc_hd__decap_12
XFILLER_0_120_1275 VGND VGND VPWR VPWR sky130_fd_sc_hd__decap_6
XFILLER_0_218_1037 VPWR VGND VPWR VGND sky130_ef_sc_hd__decap_12
XFILLER_0_155_47 VGND VGND VPWR VPWR sky130_fd_sc_hd__decap_3
XFILLER_0_80_22 VGND VGND VPWR VPWR sky130_fd_sc_hd__decap_6
XFILLER_0_171_46 VGND VGND VPWR VPWR sky130_fd_sc_hd__fill_2
XFILLER_0_191_629 VPWR VGND VPWR VGND sky130_ef_sc_hd__decap_12
XFILLER_0_6_401 VPWR VGND VPWR VGND sky130_ef_sc_hd__decap_12
XFILLER_0_89_1255 VPWR VGND VPWR VGND sky130_ef_sc_hd__decap_12
XFILLER_0_6_445 VPWR VGND VPWR VGND sky130_ef_sc_hd__decap_12
XFILLER_0_113_921 VPWR VGND VPWR VGND sky130_ef_sc_hd__decap_12
XFILLER_0_6_489 VPWR VGND VPWR VGND sky130_ef_sc_hd__decap_12
XFILLER_0_113_965 VPWR VGND VPWR VGND sky130_ef_sc_hd__decap_12
XFILLER_0_1_161 VGND VGND VPWR VPWR sky130_fd_sc_hd__decap_6
XFILLER_0_112_475 VGND VGND VPWR VPWR sky130_fd_sc_hd__fill_1
XFILLER_0_26_1283 VPWR VGND VPWR VGND sky130_ef_sc_hd__decap_12
XFILLER_0_226_365 VGND VGND VPWR VPWR sky130_fd_sc_hd__decap_8
XFILLER_0_215_39 VPWR VGND VPWR VGND sky130_ef_sc_hd__decap_12
XPHY_903 VGND VGND VPWR VPWR sky130_fd_sc_hd__decap_3
XPHY_936 VGND VGND VPWR VPWR sky130_fd_sc_hd__decap_3
XPHY_925 VGND VGND VPWR VPWR sky130_fd_sc_hd__decap_3
XFILLER_0_72_1281 VGND VGND VPWR VPWR sky130_fd_sc_hd__fill_1
XPHY_914 VGND VGND VPWR VPWR sky130_fd_sc_hd__decap_3
XPHY_958 VGND VGND VPWR VPWR sky130_fd_sc_hd__decap_3
XPHY_947 VGND VGND VPWR VPWR sky130_fd_sc_hd__decap_3
XPHY_969 VGND VGND VPWR VPWR sky130_fd_sc_hd__decap_3
XFILLER_0_108_737 VPWR VGND VPWR VGND sky130_ef_sc_hd__decap_12
XFILLER_0_80_605 VPWR VGND VPWR VGND sky130_ef_sc_hd__decap_12
XFILLER_0_107_225 VPWR VGND VPWR VGND sky130_ef_sc_hd__decap_12
XFILLER_0_68_1339 VGND VGND VPWR VPWR sky130_fd_sc_hd__decap_4
XFILLER_0_208_1239 VPWR VGND VPWR VGND sky130_ef_sc_hd__decap_12
XFILLER_0_104_921 VGND VGND VPWR VPWR sky130_fd_sc_hd__decap_3
XFILLER_0_104_965 VPWR VGND VPWR VGND sky130_ef_sc_hd__decap_12
XFILLER_0_143_1253 VGND VGND VPWR VPWR sky130_fd_sc_hd__fill_1
XFILLER_0_218_811 VGND VGND VPWR VPWR sky130_fd_sc_hd__fill_1
XFILLER_0_40_1225 VGND VGND VPWR VPWR sky130_fd_sc_hd__fill_1
XFILLER_0_219_1313 VPWR VGND VPWR VGND sky130_ef_sc_hd__decap_12
XFILLER_0_18_49 VGND VGND VPWR VPWR sky130_fd_sc_hd__fill_1
XFILLER_0_18_27 VGND VGND VPWR VPWR sky130_fd_sc_hd__fill_1
XFILLER_0_115_1311 VPWR VGND VPWR VGND sky130_ef_sc_hd__decap_12
XFILLER_0_34_15 VPWR VGND VPWR VGND sky130_ef_sc_hd__decap_12
XFILLER_0_125_39 VGND VGND VPWR VPWR sky130_fd_sc_hd__decap_8
XTAP_2351 VGND VPWR sky130_fd_sc_hd__tapvpwrvgnd_1
XTAP_2340 VGND VPWR sky130_fd_sc_hd__tapvpwrvgnd_1
XFILLER_0_150_1213 VPWR VGND VPWR VGND sky130_ef_sc_hd__decap_12
XTAP_2362 VGND VPWR sky130_fd_sc_hd__tapvpwrvgnd_1
XTAP_2395 VGND VPWR sky130_fd_sc_hd__tapvpwrvgnd_1
XTAP_2384 VGND VPWR sky130_fd_sc_hd__tapvpwrvgnd_1
XTAP_2373 VGND VPWR sky130_fd_sc_hd__tapvpwrvgnd_1
XTAP_1650 VGND VPWR sky130_fd_sc_hd__tapvpwrvgnd_1
XFILLER_0_51_1343 VGND VGND VPWR VPWR sky130_fd_sc_hd__fill_1
XFILLER_0_185_1309 VGND VGND VPWR VPWR sky130_fd_sc_hd__fill_1
XFILLER_0_173_629 VPWR VGND VPWR VGND sky130_ef_sc_hd__decap_12
XTAP_1661 VGND VPWR sky130_fd_sc_hd__tapvpwrvgnd_1
XFILLER_0_7_209 VPWR VGND VPWR VGND sky130_ef_sc_hd__decap_12
XTAP_1694 VGND VPWR sky130_fd_sc_hd__tapvpwrvgnd_1
XTAP_1672 VGND VPWR sky130_fd_sc_hd__tapvpwrvgnd_1
XTAP_1683 VGND VPWR sky130_fd_sc_hd__tapvpwrvgnd_1
XFILLER_0_141_27 VPWR VGND VPWR VGND sky130_ef_sc_hd__decap_12
XFILLER_0_71_605 VPWR VGND VPWR VGND sky130_ef_sc_hd__decap_12
XFILLER_0_126_6 VGND VGND VPWR VPWR sky130_fd_sc_hd__fill_2
XFILLER_0_4_905 VPWR VGND VPWR VGND sky130_ef_sc_hd__decap_12
XFILLER_0_226_1317 VGND VGND VPWR VPWR sky130_fd_sc_hd__decap_4
XFILLER_0_221_93 VPWR VGND VPWR VGND sky130_ef_sc_hd__decap_12
XFILLER_0_114_729 VPWR VGND VPWR VGND sky130_ef_sc_hd__decap_12
XFILLER_0_4_949 VPWR VGND VPWR VGND sky130_ef_sc_hd__decap_12
XFILLER_0_113_217 VGND VGND VPWR VPWR sky130_fd_sc_hd__decap_6
XFILLER_0_59_45 VGND VGND VPWR VPWR sky130_fd_sc_hd__decap_3
XANTENNA_u_pe00_act_in[2] net9 VGND VGND VPWR VPWR sky130_fd_sc_hd__diode_2
XFILLER_0_224_1085 VGND VGND VPWR VPWR sky130_fd_sc_hd__decap_6
XFILLER_0_122_1337 VGND VGND VPWR VPWR sky130_fd_sc_hd__fill_1
XFILLER_0_110_979 VGND VGND VPWR VPWR sky130_fd_sc_hd__fill_1
XFILLER_0_52_9 VGND VGND VPWR VPWR sky130_fd_sc_hd__fill_2
XFILLER_0_224_825 VPWR VGND VPWR VGND sky130_ef_sc_hd__decap_12
XFILLER_0_224_869 VPWR VGND VPWR VGND sky130_ef_sc_hd__decap_12
XFILLER_0_223_335 VGND VGND VPWR VPWR sky130_fd_sc_hd__fill_1
XFILLER_0_91_10 VPWR VGND VPWR VGND sky130_ef_sc_hd__decap_12
XFILLER_0_204_593 VPWR VGND VPWR VGND sky130_ef_sc_hd__decap_12
XFILLER_0_17_1249 VGND VGND VPWR VPWR sky130_fd_sc_hd__decap_4
XFILLER_0_62_605 VPWR VGND VPWR VGND sky130_ef_sc_hd__decap_12
XFILLER_0_6_253 VPWR VGND VPWR VGND sky130_ef_sc_hd__decap_12
XFILLER_0_166_1275 VGND VGND VPWR VPWR sky130_fd_sc_hd__decap_6
XFILLER_0_105_729 VPWR VGND VPWR VGND sky130_ef_sc_hd__decap_12
XFILLER_0_127_1237 VPWR VGND VPWR VGND sky130_ef_sc_hd__decap_12
XFILLER_0_63_1225 VPWR VGND VPWR VGND sky130_ef_sc_hd__decap_12
XFILLER_0_226_16 VGND VGND VPWR VPWR sky130_fd_sc_hd__fill_2
XFILLER_0_214_357 VGND VGND VPWR VPWR sky130_fd_sc_hd__decap_6
XFILLER_0_173_1213 VPWR VGND VPWR VGND sky130_ef_sc_hd__decap_12
XFILLER_0_74_1343 VGND VGND VPWR VPWR sky130_fd_sc_hd__fill_1
XFILLER_0_173_1279 VPWR VGND VPWR VGND sky130_ef_sc_hd__decap_12
XFILLER_0_210_541 VPWR VGND VPWR VGND sky130_ef_sc_hd__decap_12
XPHY_700 VGND VGND VPWR VPWR sky130_fd_sc_hd__decap_3
XPHY_711 VGND VGND VPWR VPWR sky130_fd_sc_hd__decap_3
XANTENNA_input104_A w00[12] VGND VGND VPWR VPWR sky130_fd_sc_hd__diode_2
XFILLER_0_210_585 VGND VGND VPWR VPWR sky130_fd_sc_hd__decap_3
XPHY_744 VGND VGND VPWR VPWR sky130_fd_sc_hd__decap_3
XPHY_733 VGND VGND VPWR VPWR sky130_fd_sc_hd__decap_3
XFILLER_0_155_629 VPWR VGND VPWR VGND sky130_ef_sc_hd__decap_12
XFILLER_0_108_501 VPWR VGND VPWR VGND sky130_ef_sc_hd__decap_12
XPHY_722 VGND VGND VPWR VPWR sky130_fd_sc_hd__decap_3
XFILLER_0_110_1241 VPWR VGND VPWR VGND sky130_ef_sc_hd__decap_12
XPHY_766 VGND VGND VPWR VPWR sky130_fd_sc_hd__decap_3
XPHY_755 VGND VGND VPWR VPWR sky130_fd_sc_hd__decap_3
XFILLER_0_53_605 VPWR VGND VPWR VGND sky130_ef_sc_hd__decap_12
XPHY_777 VGND VGND VPWR VPWR sky130_fd_sc_hd__decap_3
XFILLER_0_184_1331 VGND VGND VPWR VPWR sky130_fd_sc_hd__decap_6
XPHY_799 VGND VGND VPWR VPWR sky130_fd_sc_hd__decap_3
XFILLER_0_108_545 VPWR VGND VPWR VGND sky130_ef_sc_hd__decap_12
XPHY_788 VGND VGND VPWR VPWR sky130_fd_sc_hd__decap_3
XFILLER_0_110_1285 VPWR VGND VPWR VGND sky130_ef_sc_hd__decap_12
XFILLER_0_108_589 VPWR VGND VPWR VGND sky130_ef_sc_hd__decap_12
XFILLER_0_180_1239 VPWR VGND VPWR VGND sky130_ef_sc_hd__decap_12
XFILLER_0_81_1303 VGND VGND VPWR VPWR sky130_fd_sc_hd__decap_6
XFILLER_0_110_209 VPWR VGND VPWR VGND sky130_ef_sc_hd__decap_12
XFILLER_0_221_1225 VGND VGND VPWR VPWR sky130_fd_sc_hd__decap_6
XFILLER_0_29_15 VPWR VGND VPWR VGND sky130_ef_sc_hd__decap_12
XFILLER_0_221_1269 VPWR VGND VPWR VGND sky130_ef_sc_hd__decap_12
XFILLER_0_104_1089 VGND VGND VPWR VPWR sky130_fd_sc_hd__decap_3
XFILLER_0_219_1121 VPWR VGND VPWR VGND sky130_ef_sc_hd__decap_12
XFILLER_0_45_25 VPWR VGND VPWR VGND sky130_ef_sc_hd__decap_12
XFILLER_0_136_49 VGND VGND VPWR VPWR sky130_fd_sc_hd__fill_1
XFILLER_0_215_1007 VGND VGND VPWR VPWR sky130_fd_sc_hd__fill_1
XFILLER_0_221_839 VGND VGND VPWR VPWR sky130_fd_sc_hd__fill_1
XFILLER_0_152_1319 VPWR VGND VPWR VGND sky130_ef_sc_hd__decap_12
XTAP_2170 VGND VPWR sky130_fd_sc_hd__tapvpwrvgnd_1
XFILLER_0_0_27 VGND VGND VPWR VPWR sky130_fd_sc_hd__fill_1
XFILLER_0_5_1225 VGND VGND VPWR VPWR sky130_fd_sc_hd__decap_6
XFILLER_0_152_15 VPWR VGND VPWR VGND sky130_ef_sc_hd__decap_12
XTAP_2192 VGND VPWR sky130_fd_sc_hd__tapvpwrvgnd_1
XTAP_2181 VGND VPWR sky130_fd_sc_hd__tapvpwrvgnd_1
XFILLER_0_189_1253 VGND VGND VPWR VPWR sky130_fd_sc_hd__fill_1
XFILLER_0_44_605 VPWR VGND VPWR VGND sky130_ef_sc_hd__decap_12
XFILLER_0_5_1269 VPWR VGND VPWR VGND sky130_ef_sc_hd__decap_12
XTAP_1480 VGND VPWR sky130_fd_sc_hd__tapvpwrvgnd_1
XTAP_1491 VGND VPWR sky130_fd_sc_hd__tapvpwrvgnd_1
XFILLER_0_86_1225 VGND VGND VPWR VPWR sky130_fd_sc_hd__fill_1
XFILLER_0_124_3 VPWR VGND VPWR VGND sky130_ef_sc_hd__decap_12
XFILLER_0_9_47 VGND VGND VPWR VPWR sky130_fd_sc_hd__decap_3
XFILLER_0_4_713 VPWR VGND VPWR VGND sky130_ef_sc_hd__decap_12
XFILLER_0_3_223 VGND VGND VPWR VPWR sky130_fd_sc_hd__fill_1
XFILLER_0_4_757 VPWR VGND VPWR VGND sky130_ef_sc_hd__decap_12
XFILLER_0_126_1281 VGND VGND VPWR VPWR sky130_fd_sc_hd__fill_1
XFILLER_0_196_1213 VPWR VGND VPWR VGND sky130_ef_sc_hd__decap_12
XFILLER_0_209_641 VGND VGND VPWR VPWR sky130_fd_sc_hd__decap_4
XFILLER_0_23_1253 VGND VGND VPWR VPWR sky130_fd_sc_hd__fill_1
XFILLER_0_97_1343 VGND VGND VPWR VPWR sky130_fd_sc_hd__fill_1
XFILLER_0_224_699 VGND VGND VPWR VPWR sky130_fd_sc_hd__fill_1
XFILLER_0_211_305 VPWR VGND VPWR VGND sky130_ef_sc_hd__decap_12
XFILLER_0_29_3 VPWR VGND VPWR VGND sky130_ef_sc_hd__decap_12
XFILLER_0_211_349 VPWR VGND VPWR VGND sky130_ef_sc_hd__decap_12
XFILLER_0_220_861 VGND VGND VPWR VPWR sky130_fd_sc_hd__decap_6
XFILLER_0_137_629 VPWR VGND VPWR VGND sky130_ef_sc_hd__decap_12
XFILLER_0_212_29 VPWR VGND VPWR VGND sky130_ef_sc_hd__decap_12
XFILLER_0_35_605 VPWR VGND VPWR VGND sky130_ef_sc_hd__decap_12
XFILLER_0_30_1213 VPWR VGND VPWR VGND sky130_ef_sc_hd__decap_12
XFILLER_0_168_1337 VGND VGND VPWR VPWR sky130_fd_sc_hd__fill_1
XFILLER_0_209_1323 VGND VGND VPWR VPWR sky130_fd_sc_hd__decap_8
XFILLER_0_7_573 VPWR VGND VPWR VGND sky130_ef_sc_hd__decap_12
XFILLER_0_65_1309 VGND VGND VPWR VPWR sky130_fd_sc_hd__fill_1
XFILLER_0_160_643 VPWR VGND VPWR VGND sky130_ef_sc_hd__decap_12
XFILLER_0_105_559 VGND VGND VPWR VPWR sky130_fd_sc_hd__fill_1
XFILLER_0_50_619 VPWR VGND VPWR VGND sky130_ef_sc_hd__decap_12
XFILLER_0_219_405 VPWR VGND VPWR VGND sky130_ef_sc_hd__decap_12
XFILLER_0_140_1201 VPWR VGND VPWR VGND sky130_ef_sc_hd__decap_12
XFILLER_0_219_449 VPWR VGND VPWR VGND sky130_ef_sc_hd__decap_12
XFILLER_0_105_1343 VGND VGND VPWR VPWR sky130_fd_sc_hd__fill_1
XFILLER_0_214_121 VPWR VGND VPWR VGND sky130_ef_sc_hd__decap_12
XFILLER_0_214_165 VPWR VGND VPWR VGND sky130_ef_sc_hd__decap_12
XFILLER_0_15_39 VGND VGND VPWR VPWR sky130_fd_sc_hd__decap_8
XFILLER_0_214_1073 VPWR VGND VPWR VGND sky130_ef_sc_hd__decap_12
XFILLER_0_210_393 VPWR VGND VPWR VGND sky130_ef_sc_hd__decap_12
XPHY_530 VGND VGND VPWR VPWR sky130_fd_sc_hd__decap_3
XFILLER_0_109_821 VPWR VGND VPWR VGND sky130_ef_sc_hd__decap_12
XPHY_552 VGND VGND VPWR VPWR sky130_fd_sc_hd__decap_3
XPHY_541 VGND VGND VPWR VPWR sky130_fd_sc_hd__decap_3
XFILLER_0_26_605 VPWR VGND VPWR VGND sky130_ef_sc_hd__decap_12
XFILLER_0_122_29 VPWR VGND VPWR VGND sky130_ef_sc_hd__decap_12
XPHY_1140 VGND VGND VPWR VPWR sky130_fd_sc_hd__decap_3
XPHY_585 VGND VGND VPWR VPWR sky130_fd_sc_hd__decap_3
XFILLER_0_109_865 VPWR VGND VPWR VGND sky130_ef_sc_hd__decap_12
XFILLER_0_93_593 VPWR VGND VPWR VGND sky130_ef_sc_hd__decap_12
XPHY_563 VGND VGND VPWR VPWR sky130_fd_sc_hd__decap_3
XPHY_574 VGND VGND VPWR VPWR sky130_fd_sc_hd__decap_3
XPHY_596 VGND VGND VPWR VPWR sky130_fd_sc_hd__decap_3
XPHY_1162 VGND VGND VPWR VPWR sky130_fd_sc_hd__decap_3
XPHY_1151 VGND VGND VPWR VPWR sky130_fd_sc_hd__decap_3
XPHY_1184 VGND VGND VPWR VPWR sky130_fd_sc_hd__decap_3
XPHY_1173 VGND VGND VPWR VPWR sky130_fd_sc_hd__decap_3
XFILLER_0_0_1155 VPWR VGND VPWR VGND sky130_ef_sc_hd__decap_12
XPHY_1195 VGND VGND VPWR VPWR sky130_fd_sc_hd__decap_3
XFILLER_0_110_1093 VPWR VGND VPWR VGND sky130_ef_sc_hd__decap_12
XFILLER_0_0_1177 VPWR VGND VPWR VGND sky130_ef_sc_hd__decap_12
XFILLER_0_1_727 VGND VGND VPWR VPWR sky130_fd_sc_hd__fill_1
XFILLER_0_85_1291 VPWR VGND VPWR VGND sky130_ef_sc_hd__decap_12
XFILLER_0_106_1129 VPWR VGND VPWR VGND sky130_ef_sc_hd__decap_12
XFILLER_0_111_529 VPWR VGND VPWR VGND sky130_ef_sc_hd__decap_12
XFILLER_0_46_1275 VGND VGND VPWR VPWR sky130_fd_sc_hd__decap_6
XFILLER_0_221_1033 VPWR VGND VPWR VGND sky130_ef_sc_hd__decap_12
XFILLER_0_221_1077 VPWR VGND VPWR VGND sky130_ef_sc_hd__decap_12
XFILLER_0_56_13 VPWR VGND VPWR VGND sky130_ef_sc_hd__decap_12
XFILLER_0_206_655 VGND VGND VPWR VPWR sky130_fd_sc_hd__decap_4
XFILLER_0_156_1263 VPWR VGND VPWR VGND sky130_ef_sc_hd__decap_12
XFILLER_0_117_1225 VPWR VGND VPWR VGND sky130_ef_sc_hd__decap_12
XFILLER_0_92_1251 VPWR VGND VPWR VGND sky130_ef_sc_hd__decap_12
XFILLER_0_163_47 VGND VGND VPWR VPWR sky130_fd_sc_hd__decap_3
XFILLER_0_53_1213 VPWR VGND VPWR VGND sky130_ef_sc_hd__decap_12
XFILLER_0_92_1295 VPWR VGND VPWR VGND sky130_ef_sc_hd__decap_12
XFILLER_0_5_1033 VPWR VGND VPWR VGND sky130_ef_sc_hd__decap_12
XFILLER_0_53_1279 VPWR VGND VPWR VGND sky130_ef_sc_hd__decap_12
XFILLER_0_119_629 VPWR VGND VPWR VGND sky130_ef_sc_hd__decap_12
XFILLER_0_17_605 VPWR VGND VPWR VGND sky130_ef_sc_hd__decap_12
XFILLER_0_84_593 VPWR VGND VPWR VGND sky130_ef_sc_hd__decap_12
XFILLER_0_5_1077 VPWR VGND VPWR VGND sky130_ef_sc_hd__decap_12
XFILLER_0_98_6 VGND VGND VPWR VPWR sky130_fd_sc_hd__fill_2
XFILLER_0_163_1201 VPWR VGND VPWR VGND sky130_ef_sc_hd__decap_12
XFILLER_0_142_643 VPWR VGND VPWR VGND sky130_ef_sc_hd__decap_12
XFILLER_0_32_619 VPWR VGND VPWR VGND sky130_ef_sc_hd__decap_12
XFILLER_0_128_1343 VGND VGND VPWR VPWR sky130_fd_sc_hd__fill_1
XFILLER_0_64_1331 VGND VGND VPWR VPWR sky130_fd_sc_hd__decap_6
XFILLER_0_163_1267 VPWR VGND VPWR VGND sky130_ef_sc_hd__decap_12
XFILLER_0_4_587 VGND VGND VPWR VPWR sky130_fd_sc_hd__fill_1
XFILLER_0_114_389 VGND VGND VPWR VPWR sky130_fd_sc_hd__decap_3
XFILLER_0_198_1319 VPWR VGND VPWR VGND sky130_ef_sc_hd__decap_12
XFILLER_0_60_1239 VPWR VGND VPWR VGND sky130_ef_sc_hd__decap_12
XFILLER_0_204_1275 VGND VGND VPWR VPWR sky130_fd_sc_hd__decap_6
XFILLER_0_217_909 VPWR VGND VPWR VGND sky130_ef_sc_hd__decap_12
XFILLER_0_0_771 VGND VGND VPWR VPWR sky130_fd_sc_hd__fill_2
XFILLER_0_216_419 VGND VGND VPWR VPWR sky130_fd_sc_hd__fill_1
XFILLER_0_0_793 VGND VGND VPWR VPWR sky130_fd_sc_hd__fill_2
XFILLER_0_225_953 VPWR VGND VPWR VGND sky130_ef_sc_hd__decap_12
XFILLER_0_100_1251 VPWR VGND VPWR VGND sky130_ef_sc_hd__decap_12
XFILLER_0_135_1303 VGND VGND VPWR VPWR sky130_fd_sc_hd__decap_6
XFILLER_0_100_1295 VPWR VGND VPWR VGND sky130_ef_sc_hd__decap_12
XTAP_2917 VGND VPWR sky130_fd_sc_hd__tapvpwrvgnd_1
XTAP_2906 VGND VPWR sky130_fd_sc_hd__tapvpwrvgnd_1
XFILLER_0_212_625 VPWR VGND VPWR VGND sky130_ef_sc_hd__decap_12
XTAP_2928 VGND VPWR sky130_fd_sc_hd__tapvpwrvgnd_1
XFILLER_0_211_113 VPWR VGND VPWR VGND sky130_ef_sc_hd__decap_12
XTAP_2939 VGND VPWR sky130_fd_sc_hd__tapvpwrvgnd_1
XFILLER_0_212_669 VPWR VGND VPWR VGND sky130_ef_sc_hd__decap_12
XFILLER_0_170_1227 VPWR VGND VPWR VGND sky130_ef_sc_hd__decap_12
XFILLER_0_71_1335 VGND VGND VPWR VPWR sky130_fd_sc_hd__fill_1
XFILLER_0_211_1213 VPWR VGND VPWR VGND sky130_ef_sc_hd__decap_12
XFILLER_0_223_39 VPWR VGND VPWR VGND sky130_ef_sc_hd__decap_12
XFILLER_0_1_81 VPWR VGND VPWR VGND sky130_ef_sc_hd__decap_12
XFILLER_0_32_1319 VPWR VGND VPWR VGND sky130_ef_sc_hd__decap_12
XFILLER_0_211_1257 VPWR VGND VPWR VGND sky130_ef_sc_hd__decap_12
XFILLER_0_106_813 VPWR VGND VPWR VGND sky130_ef_sc_hd__decap_12
XFILLER_0_75_593 VPWR VGND VPWR VGND sky130_ef_sc_hd__decap_12
XFILLER_0_69_1253 VGND VGND VPWR VPWR sky130_fd_sc_hd__fill_1
XFILLER_0_181_1323 VPWR VGND VPWR VGND sky130_ef_sc_hd__decap_12
XFILLER_0_142_1307 VPWR VGND VPWR VGND sky130_ef_sc_hd__decap_12
XFILLER_0_31_641 VGND VGND VPWR VPWR sky130_fd_sc_hd__decap_4
XFILLER_0_219_279 VGND VGND VPWR VPWR sky130_fd_sc_hd__fill_1
XFILLER_0_76_1213 VPWR VGND VPWR VGND sky130_ef_sc_hd__decap_12
XANTENNA_input32_A act_row1_in[9] VGND VGND VPWR VPWR sky130_fd_sc_hd__diode_2
XFILLER_0_215_441 VGND VGND VPWR VPWR sky130_fd_sc_hd__decap_6
XFILLER_0_26_27 VGND VGND VPWR VPWR sky130_fd_sc_hd__fill_1
XFILLER_0_203_647 VPWR VGND VPWR VGND sky130_ef_sc_hd__decap_12
XFILLER_0_215_485 VPWR VGND VPWR VGND sky130_ef_sc_hd__decap_12
XFILLER_0_26_49 VGND VGND VPWR VPWR sky130_fd_sc_hd__fill_1
XFILLER_0_186_1201 VPWR VGND VPWR VGND sky130_ef_sc_hd__decap_12
XPHY_360 VGND VGND VPWR VPWR sky130_fd_sc_hd__decap_3
XFILLER_0_2_1217 VPWR VGND VPWR VGND sky130_ef_sc_hd__decap_12
XFILLER_0_109_673 VPWR VGND VPWR VGND sky130_ef_sc_hd__decap_12
XPHY_382 VGND VGND VPWR VPWR sky130_fd_sc_hd__decap_3
XPHY_371 VGND VGND VPWR VPWR sky130_fd_sc_hd__decap_3
XFILLER_0_5_329 VGND VGND VPWR VPWR sky130_fd_sc_hd__decap_6
XFILLER_0_66_593 VPWR VGND VPWR VGND sky130_ef_sc_hd__decap_12
XPHY_393 VGND VGND VPWR VPWR sky130_fd_sc_hd__decap_3
XFILLER_0_124_643 VPWR VGND VPWR VGND sky130_ef_sc_hd__decap_12
XFILLER_0_14_619 VPWR VGND VPWR VGND sky130_ef_sc_hd__decap_12
XFILLER_0_112_805 VGND VGND VPWR VPWR sky130_fd_sc_hd__decap_6
XFILLER_0_48_1337 VGND VGND VPWR VPWR sky130_fd_sc_hd__fill_1
XFILLER_0_112_849 VPWR VGND VPWR VGND sky130_ef_sc_hd__decap_12
XFILLER_0_6_15 VPWR VGND VPWR VGND sky130_ef_sc_hd__decap_12
XFILLER_0_111_337 VPWR VGND VPWR VGND sky130_ef_sc_hd__decap_12
XFILLER_0_191_3 VPWR VGND VPWR VGND sky130_ef_sc_hd__decap_12
XFILLER_0_225_205 VPWR VGND VPWR VGND sky130_ef_sc_hd__decap_12
XFILLER_0_20_1201 VPWR VGND VPWR VGND sky130_ef_sc_hd__decap_12
XFILLER_0_225_249 VPWR VGND VPWR VGND sky130_ef_sc_hd__decap_12
XFILLER_0_193_1249 VGND VGND VPWR VPWR sky130_fd_sc_hd__decap_4
XFILLER_0_119_1309 VGND VGND VPWR VPWR sky130_fd_sc_hd__fill_1
XFILLER_0_222_923 VGND VGND VPWR VPWR sky130_fd_sc_hd__fill_1
XFILLER_0_89_641 VGND VGND VPWR VPWR sky130_fd_sc_hd__decap_4
XFILLER_0_107_51 VGND VGND VPWR VPWR sky130_fd_sc_hd__decap_4
XPHY_19 VGND VGND VPWR VPWR sky130_fd_sc_hd__decap_3
XFILLER_0_7_1117 VGND VGND VPWR VPWR sky130_fd_sc_hd__decap_3
XFILLER_0_57_593 VPWR VGND VPWR VGND sky130_ef_sc_hd__decap_12
XFILLER_0_106_109 VPWR VGND VPWR VGND sky130_ef_sc_hd__decap_12
XFILLER_0_5_841 VPWR VGND VPWR VGND sky130_ef_sc_hd__decap_12
XFILLER_0_96_3 VPWR VGND VPWR VGND sky130_ef_sc_hd__decap_12
XFILLER_0_114_153 VPWR VGND VPWR VGND sky130_ef_sc_hd__decap_12
XFILLER_0_206_1337 VGND VGND VPWR VPWR sky130_fd_sc_hd__fill_1
XFILLER_0_13_641 VGND VGND VPWR VPWR sky130_fd_sc_hd__decap_4
XFILLER_0_114_197 VPWR VGND VPWR VGND sky130_ef_sc_hd__decap_12
XFILLER_0_99_1213 VPWR VGND VPWR VGND sky130_ef_sc_hd__decap_12
XFILLER_0_99_1279 VPWR VGND VPWR VGND sky130_ef_sc_hd__decap_12
XTAP_2703 VGND VPWR sky130_fd_sc_hd__tapvpwrvgnd_1
XFILLER_0_225_783 VGND VGND VPWR VPWR sky130_fd_sc_hd__fill_1
XFILLER_0_213_945 VGND VGND VPWR VPWR sky130_fd_sc_hd__decap_6
XFILLER_0_213_989 VPWR VGND VPWR VGND sky130_ef_sc_hd__decap_12
XTAP_2725 VGND VPWR sky130_fd_sc_hd__tapvpwrvgnd_1
XTAP_2714 VGND VPWR sky130_fd_sc_hd__tapvpwrvgnd_1
XTAP_2736 VGND VPWR sky130_fd_sc_hd__tapvpwrvgnd_1
XFILLER_0_212_433 VPWR VGND VPWR VGND sky130_ef_sc_hd__decap_12
XFILLER_0_139_1291 VPWR VGND VPWR VGND sky130_ef_sc_hd__decap_12
XTAP_2769 VGND VPWR sky130_fd_sc_hd__tapvpwrvgnd_1
XTAP_2747 VGND VPWR sky130_fd_sc_hd__tapvpwrvgnd_1
XFILLER_0_200_617 VGND VGND VPWR VPWR sky130_fd_sc_hd__fill_1
XTAP_2758 VGND VPWR sky130_fd_sc_hd__tapvpwrvgnd_1
XFILLER_0_212_477 VPWR VGND VPWR VGND sky130_ef_sc_hd__decap_12
XFILLER_0_36_1263 VPWR VGND VPWR VGND sky130_ef_sc_hd__decap_12
XFILLER_0_211_1021 VPWR VGND VPWR VGND sky130_ef_sc_hd__decap_12
XFILLER_0_211_1065 VPWR VGND VPWR VGND sky130_ef_sc_hd__decap_12
XFILLER_0_12_29 VPWR VGND VPWR VGND sky130_ef_sc_hd__decap_12
XFILLER_0_48_593 VPWR VGND VPWR VGND sky130_ef_sc_hd__decap_12
XFILLER_0_106_643 VGND VGND VPWR VPWR sky130_fd_sc_hd__fill_1
XFILLER_0_146_1251 VPWR VGND VPWR VGND sky130_ef_sc_hd__decap_12
XFILLER_0_107_1213 VPWR VGND VPWR VGND sky130_ef_sc_hd__decap_12
XFILLER_0_146_1295 VPWR VGND VPWR VGND sky130_ef_sc_hd__decap_12
XFILLER_0_107_1257 VPWR VGND VPWR VGND sky130_ef_sc_hd__decap_12
XFILLER_0_43_1201 VPWR VGND VPWR VGND sky130_ef_sc_hd__decap_12
XFILLER_0_222_1161 VPWR VGND VPWR VGND sky130_ef_sc_hd__decap_12
XFILLER_0_82_1283 VPWR VGND VPWR VGND sky130_ef_sc_hd__decap_12
XFILLER_0_37_15 VPWR VGND VPWR VGND sky130_ef_sc_hd__decap_12
XFILLER_0_43_1267 VPWR VGND VPWR VGND sky130_ef_sc_hd__decap_12
XFILLER_0_78_1319 VPWR VGND VPWR VGND sky130_ef_sc_hd__decap_12
Xinput151 w11[11] VGND VGND VPWR VPWR net151 sky130_fd_sc_hd__clkbuf_8
XFILLER_0_223_709 VPWR VGND VPWR VGND sky130_ef_sc_hd__decap_12
Xinput140 w10[1] VGND VGND VPWR VPWR net140 sky130_fd_sc_hd__clkbuf_4
Xinput162 w11[7] VGND VGND VPWR VPWR net162 sky130_fd_sc_hd__buf_4
XFILLER_0_215_293 VPWR VGND VPWR VGND sky130_ef_sc_hd__decap_12
XFILLER_0_118_1331 VGND VGND VPWR VPWR sky130_fd_sc_hd__decap_6
XFILLER_0_144_27 VGND VGND VPWR VPWR sky130_fd_sc_hd__fill_1
XFILLER_0_144_49 VGND VGND VPWR VPWR sky130_fd_sc_hd__fill_1
XFILLER_0_153_1255 VPWR VGND VPWR VGND sky130_ef_sc_hd__decap_12
XFILLER_0_114_1217 VPWR VGND VPWR VGND sky130_ef_sc_hd__decap_12
XFILLER_0_53_47 VGND VGND VPWR VPWR sky130_fd_sc_hd__fill_1
XFILLER_0_15_1303 VGND VGND VPWR VPWR sky130_fd_sc_hd__decap_6
XFILLER_0_188_1307 VPWR VGND VPWR VGND sky130_ef_sc_hd__decap_12
XFILLER_0_86_655 VGND VGND VPWR VPWR sky130_fd_sc_hd__decap_4
XFILLER_0_50_1227 VPWR VGND VPWR VGND sky130_ef_sc_hd__decap_12
XFILLER_0_6_1161 VPWR VGND VPWR VGND sky130_ef_sc_hd__decap_12
XFILLER_0_160_15 VPWR VGND VPWR VGND sky130_ef_sc_hd__decap_12
XFILLER_0_39_593 VPWR VGND VPWR VGND sky130_ef_sc_hd__decap_12
XPHY_190 VGND VGND VPWR VPWR sky130_fd_sc_hd__decap_3
XFILLER_0_5_137 VPWR VGND VPWR VGND sky130_ef_sc_hd__decap_12
XFILLER_0_204_3 VPWR VGND VPWR VGND sky130_ef_sc_hd__decap_12
XFILLER_0_112_613 VPWR VGND VPWR VGND sky130_ef_sc_hd__decap_12
XFILLER_0_2_811 VGND VGND VPWR VPWR sky130_fd_sc_hd__fill_1
XFILLER_0_125_1335 VGND VGND VPWR VPWR sky130_fd_sc_hd__fill_1
XFILLER_0_112_657 VPWR VGND VPWR VGND sky130_ef_sc_hd__decap_12
XFILLER_0_201_1201 VPWR VGND VPWR VGND sky130_ef_sc_hd__decap_12
XFILLER_0_22_1307 VPWR VGND VPWR VGND sky130_ef_sc_hd__decap_12
XFILLER_0_61_1323 VPWR VGND VPWR VGND sky130_ef_sc_hd__decap_12
XFILLER_0_111_167 VGND VGND VPWR VPWR sky130_fd_sc_hd__fill_1
XFILLER_0_10_655 VGND VGND VPWR VPWR sky130_fd_sc_hd__decap_4
XFILLER_0_94_10 VPWR VGND VPWR VGND sky130_ef_sc_hd__decap_12
XFILLER_0_201_1267 VPWR VGND VPWR VGND sky130_ef_sc_hd__decap_12
XFILLER_0_226_536 VGND VGND VPWR VPWR sky130_fd_sc_hd__fill_2
XFILLER_0_185_45 VGND VGND VPWR VPWR sky130_fd_sc_hd__decap_3
XFILLER_0_171_1311 VPWR VGND VPWR VGND sky130_ef_sc_hd__decap_12
XFILLER_0_210_937 VGND VGND VPWR VPWR sky130_fd_sc_hd__fill_1
XFILLER_0_194_605 VPWR VGND VPWR VGND sky130_ef_sc_hd__decap_12
XFILLER_0_11_3 VPWR VGND VPWR VGND sky130_ef_sc_hd__decap_12
XTAP_1309 VGND VPWR sky130_fd_sc_hd__tapvpwrvgnd_1
XFILLER_0_212_1341 VGND VGND VPWR VPWR sky130_fd_sc_hd__decap_3
XFILLER_0_132_1339 VGND VGND VPWR VPWR sky130_fd_sc_hd__decap_4
XFILLER_0_77_655 VGND VGND VPWR VPWR sky130_fd_sc_hd__fill_2
XFILLER_0_66_1201 VPWR VGND VPWR VGND sky130_ef_sc_hd__decap_12
XFILLER_0_107_429 VPWR VGND VPWR VGND sky130_ef_sc_hd__decap_12
XFILLER_0_220_29 VPWR VGND VPWR VGND sky130_ef_sc_hd__decap_12
XFILLER_0_5_671 VGND VGND VPWR VPWR sky130_fd_sc_hd__fill_1
XFILLER_0_217_503 VGND VGND VPWR VPWR sky130_fd_sc_hd__fill_1
XANTENNA_input134_A w10[10] VGND VGND VPWR VPWR sky130_fd_sc_hd__diode_2
XTAP_2511 VGND VPWR sky130_fd_sc_hd__tapvpwrvgnd_1
XTAP_2500 VGND VPWR sky130_fd_sc_hd__tapvpwrvgnd_1
XFILLER_0_213_753 VPWR VGND VPWR VGND sky130_ef_sc_hd__decap_12
XFILLER_0_213_797 VPWR VGND VPWR VGND sky130_ef_sc_hd__decap_12
XTAP_2544 VGND VPWR sky130_fd_sc_hd__tapvpwrvgnd_1
XFILLER_0_185_605 VPWR VGND VPWR VGND sky130_ef_sc_hd__decap_12
XTAP_2533 VGND VPWR sky130_fd_sc_hd__tapvpwrvgnd_1
XTAP_2522 VGND VPWR sky130_fd_sc_hd__tapvpwrvgnd_1
XFILLER_0_73_1249 VGND VGND VPWR VPWR sky130_fd_sc_hd__decap_4
XTAP_2566 VGND VPWR sky130_fd_sc_hd__tapvpwrvgnd_1
XTAP_2588 VGND VPWR sky130_fd_sc_hd__tapvpwrvgnd_1
XTAP_2555 VGND VPWR sky130_fd_sc_hd__tapvpwrvgnd_1
XTAP_2577 VGND VPWR sky130_fd_sc_hd__tapvpwrvgnd_1
XTAP_1832 VGND VPWR sky130_fd_sc_hd__tapvpwrvgnd_1
XTAP_1810 VGND VPWR sky130_fd_sc_hd__tapvpwrvgnd_1
XFILLER_0_68_655 VGND VGND VPWR VPWR sky130_fd_sc_hd__decap_4
XTAP_1821 VGND VPWR sky130_fd_sc_hd__tapvpwrvgnd_1
XTAP_1843 VGND VPWR sky130_fd_sc_hd__tapvpwrvgnd_1
XFILLER_0_114_19 VGND VGND VPWR VPWR sky130_fd_sc_hd__decap_8
XTAP_2599 VGND VPWR sky130_fd_sc_hd__tapvpwrvgnd_1
XTAP_1876 VGND VPWR sky130_fd_sc_hd__tapvpwrvgnd_1
XTAP_1865 VGND VPWR sky130_fd_sc_hd__tapvpwrvgnd_1
XTAP_1854 VGND VPWR sky130_fd_sc_hd__tapvpwrvgnd_1
XFILLER_0_23_39 VGND VGND VPWR VPWR sky130_fd_sc_hd__decap_8
XFILLER_0_3_1301 VPWR VGND VPWR VGND sky130_ef_sc_hd__decap_12
XTAP_1898 VGND VPWR sky130_fd_sc_hd__tapvpwrvgnd_1
XFILLER_0_83_647 VPWR VGND VPWR VGND sky130_ef_sc_hd__decap_12
XTAP_1887 VGND VPWR sky130_fd_sc_hd__tapvpwrvgnd_1
XFILLER_0_183_1237 VPWR VGND VPWR VGND sky130_ef_sc_hd__decap_12
XFILLER_0_130_29 VPWR VGND VPWR VGND sky130_ef_sc_hd__decap_12
XFILLER_0_107_1021 VPWR VGND VPWR VGND sky130_ef_sc_hd__decap_12
XFILLER_0_107_1065 VPWR VGND VPWR VGND sky130_ef_sc_hd__decap_12
XFILLER_0_139_27 VPWR VGND VPWR VGND sky130_ef_sc_hd__decap_12
XFILLER_0_218_1005 VPWR VGND VPWR VGND sky130_ef_sc_hd__decap_12
XFILLER_0_219_93 VPWR VGND VPWR VGND sky130_ef_sc_hd__decap_12
XFILLER_0_155_15 VPWR VGND VPWR VGND sky130_ef_sc_hd__decap_12
XFILLER_0_223_517 VPWR VGND VPWR VGND sky130_ef_sc_hd__decap_12
XFILLER_0_218_1049 VPWR VGND VPWR VGND sky130_ef_sc_hd__decap_12
XFILLER_0_8_1201 VPWR VGND VPWR VGND sky130_ef_sc_hd__decap_12
XFILLER_0_176_605 VPWR VGND VPWR VGND sky130_ef_sc_hd__decap_12
XFILLER_0_59_655 VGND VGND VPWR VPWR sky130_fd_sc_hd__fill_2
XFILLER_0_89_1201 VPWR VGND VPWR VGND sky130_ef_sc_hd__decap_12
XFILLER_0_19_1291 VPWR VGND VPWR VGND sky130_ef_sc_hd__decap_12
XFILLER_0_7_925 VPWR VGND VPWR VGND sky130_ef_sc_hd__decap_12
XFILLER_0_104_41 VPWR VGND VPWR VGND sky130_ef_sc_hd__decap_12
XFILLER_0_89_1267 VPWR VGND VPWR VGND sky130_ef_sc_hd__decap_12
XFILLER_0_6_413 VGND VGND VPWR VPWR sky130_fd_sc_hd__decap_6
XFILLER_0_104_85 VPWR VGND VPWR VGND sky130_ef_sc_hd__decap_12
XFILLER_0_6_457 VPWR VGND VPWR VGND sky130_ef_sc_hd__decap_12
XFILLER_0_225_1009 VPWR VGND VPWR VGND sky130_ef_sc_hd__decap_12
XFILLER_0_113_933 VPWR VGND VPWR VGND sky130_ef_sc_hd__decap_12
XFILLER_0_80_6 VGND VGND VPWR VPWR sky130_fd_sc_hd__fill_2
XFILLER_0_112_421 VPWR VGND VPWR VGND sky130_ef_sc_hd__decap_12
XFILLER_0_113_977 VPWR VGND VPWR VGND sky130_ef_sc_hd__decap_12
XFILLER_0_100_605 VPWR VGND VPWR VGND sky130_ef_sc_hd__decap_12
XFILLER_0_199_1255 VPWR VGND VPWR VGND sky130_ef_sc_hd__decap_12
XFILLER_0_26_1251 VPWR VGND VPWR VGND sky130_ef_sc_hd__decap_12
XFILLER_0_26_1295 VPWR VGND VPWR VGND sky130_ef_sc_hd__decap_12
XFILLER_0_96_1227 VPWR VGND VPWR VGND sky130_ef_sc_hd__decap_12
XFILLER_0_210_701 VPWR VGND VPWR VGND sky130_ef_sc_hd__decap_12
XFILLER_0_167_605 VPWR VGND VPWR VGND sky130_ef_sc_hd__decap_12
XFILLER_0_136_1283 VPWR VGND VPWR VGND sky130_ef_sc_hd__decap_12
XPHY_904 VGND VGND VPWR VPWR sky130_fd_sc_hd__decap_3
XPHY_926 VGND VGND VPWR VPWR sky130_fd_sc_hd__decap_3
XPHY_915 VGND VGND VPWR VPWR sky130_fd_sc_hd__decap_3
XFILLER_0_182_619 VPWR VGND VPWR VGND sky130_ef_sc_hd__decap_12
XPHY_948 VGND VGND VPWR VPWR sky130_fd_sc_hd__decap_3
XPHY_937 VGND VGND VPWR VPWR sky130_fd_sc_hd__decap_3
XPHY_959 VGND VGND VPWR VPWR sky130_fd_sc_hd__decap_3
XFILLER_0_65_647 VGND VGND VPWR VPWR sky130_fd_sc_hd__decap_8
XFILLER_0_33_1255 VPWR VGND VPWR VGND sky130_ef_sc_hd__decap_12
XFILLER_0_108_749 VGND VGND VPWR VPWR sky130_fd_sc_hd__decap_6
XFILLER_0_80_617 VGND VGND VPWR VPWR sky130_fd_sc_hd__fill_1
XFILLER_0_68_1307 VPWR VGND VPWR VGND sky130_ef_sc_hd__decap_12
XFILLER_0_107_237 VPWR VGND VPWR VGND sky130_ef_sc_hd__decap_12
XFILLER_0_108_1341 VGND VGND VPWR VPWR sky130_fd_sc_hd__decap_3
XFILLER_0_182_1281 VGND VGND VPWR VPWR sky130_fd_sc_hd__fill_1
XFILLER_0_104_1205 VPWR VGND VPWR VGND sky130_ef_sc_hd__decap_12
XFILLER_0_104_977 VGND VGND VPWR VPWR sky130_fd_sc_hd__decap_3
XFILLER_0_178_1339 VGND VGND VPWR VPWR sky130_fd_sc_hd__decap_3
XFILLER_0_218_867 VGND VGND VPWR VPWR sky130_fd_sc_hd__fill_1
XFILLER_0_219_1325 VPWR VGND VPWR VGND sky130_ef_sc_hd__decap_12
XFILLER_0_213_561 VPWR VGND VPWR VGND sky130_ef_sc_hd__decap_12
XFILLER_0_158_605 VPWR VGND VPWR VGND sky130_ef_sc_hd__decap_12
XFILLER_0_34_27 VGND VGND VPWR VPWR sky130_fd_sc_hd__fill_1
XTAP_2352 VGND VPWR sky130_fd_sc_hd__tapvpwrvgnd_1
XTAP_2341 VGND VPWR sky130_fd_sc_hd__tapvpwrvgnd_1
XFILLER_0_150_1225 VGND VGND VPWR VPWR sky130_fd_sc_hd__fill_1
XFILLER_0_115_1323 VPWR VGND VPWR VGND sky130_ef_sc_hd__decap_12
XTAP_2330 VGND VPWR sky130_fd_sc_hd__tapvpwrvgnd_1
XFILLER_0_34_49 VGND VGND VPWR VPWR sky130_fd_sc_hd__fill_1
XTAP_2396 VGND VPWR sky130_fd_sc_hd__tapvpwrvgnd_1
XTAP_2385 VGND VPWR sky130_fd_sc_hd__tapvpwrvgnd_1
XTAP_2363 VGND VPWR sky130_fd_sc_hd__tapvpwrvgnd_1
XTAP_2374 VGND VPWR sky130_fd_sc_hd__tapvpwrvgnd_1
XFILLER_0_51_1311 VPWR VGND VPWR VGND sky130_ef_sc_hd__decap_12
XTAP_1640 VGND VPWR sky130_fd_sc_hd__tapvpwrvgnd_1
XTAP_1651 VGND VPWR sky130_fd_sc_hd__tapvpwrvgnd_1
XFILLER_0_50_15 VPWR VGND VPWR VGND sky130_ef_sc_hd__decap_12
XTAP_1662 VGND VPWR sky130_fd_sc_hd__tapvpwrvgnd_1
XTAP_1673 VGND VPWR sky130_fd_sc_hd__tapvpwrvgnd_1
XTAP_1684 VGND VPWR sky130_fd_sc_hd__tapvpwrvgnd_1
XFILLER_0_71_617 VPWR VGND VPWR VGND sky130_ef_sc_hd__decap_12
XFILLER_0_12_1339 VGND VGND VPWR VPWR sky130_fd_sc_hd__decap_4
XTAP_1695 VGND VPWR sky130_fd_sc_hd__tapvpwrvgnd_1
XFILLER_0_141_39 VGND VGND VPWR VPWR sky130_fd_sc_hd__decap_8
XFILLER_0_181_641 VGND VGND VPWR VPWR sky130_fd_sc_hd__decap_4
XFILLER_0_4_917 VGND VGND VPWR VPWR sky130_fd_sc_hd__decap_6
XFILLER_0_3_1175 VGND VGND VPWR VPWR sky130_fd_sc_hd__fill_1
XFILLER_0_119_6 VGND VGND VPWR VPWR sky130_fd_sc_hd__fill_2
XFILLER_0_3_405 VPWR VGND VPWR VGND sky130_ef_sc_hd__decap_12
XFILLER_0_59_13 VPWR VGND VPWR VGND sky130_ef_sc_hd__decap_12
XFILLER_0_3_449 VPWR VGND VPWR VGND sky130_ef_sc_hd__decap_12
XFILLER_0_110_925 VPWR VGND VPWR VGND sky130_ef_sc_hd__decap_12
XANTENNA_u_pe00_act_in[1] net8 VGND VGND VPWR VPWR sky130_fd_sc_hd__diode_2
XFILLER_0_45_9 VGND VGND VPWR VPWR sky130_fd_sc_hd__fill_2
XFILLER_0_224_837 VPWR VGND VPWR VGND sky130_ef_sc_hd__decap_12
XFILLER_0_182_13 VPWR VGND VPWR VGND sky130_ef_sc_hd__decap_12
XFILLER_0_91_22 VPWR VGND VPWR VGND sky130_ef_sc_hd__decap_12
XFILLER_0_149_605 VPWR VGND VPWR VGND sky130_ef_sc_hd__decap_12
XFILLER_0_164_619 VPWR VGND VPWR VGND sky130_ef_sc_hd__decap_12
XFILLER_0_47_647 VGND VGND VPWR VPWR sky130_fd_sc_hd__decap_8
XFILLER_0_62_617 VGND VGND VPWR VPWR sky130_fd_sc_hd__fill_1
XFILLER_0_6_221 VPWR VGND VPWR VGND sky130_ef_sc_hd__decap_12
XFILLER_0_6_265 VPWR VGND VPWR VGND sky130_ef_sc_hd__decap_12
XFILLER_0_127_1249 VGND VGND VPWR VPWR sky130_fd_sc_hd__decap_4
XFILLER_0_113_741 VPWR VGND VPWR VGND sky130_ef_sc_hd__decap_12
XFILLER_0_63_1237 VPWR VGND VPWR VGND sky130_ef_sc_hd__decap_12
XFILLER_0_112_251 VGND VGND VPWR VPWR sky130_fd_sc_hd__fill_1
XFILLER_0_219_609 VGND VGND VPWR VPWR sky130_fd_sc_hd__decap_6
XFILLER_0_140_593 VPWR VGND VPWR VGND sky130_ef_sc_hd__decap_12
XFILLER_0_113_785 VPWR VGND VPWR VGND sky130_ef_sc_hd__decap_12
Xoutput230 net230 VGND VGND VPWR VPWR valid_row1_out sky130_fd_sc_hd__clkbuf_4
XFILLER_0_226_141 VPWR VGND VPWR VGND sky130_ef_sc_hd__decap_12
XFILLER_0_173_1225 VPWR VGND VPWR VGND sky130_ef_sc_hd__decap_12
XFILLER_0_210_553 VGND VGND VPWR VPWR sky130_fd_sc_hd__fill_1
XPHY_701 VGND VGND VPWR VPWR sky130_fd_sc_hd__decap_3
XPHY_745 VGND VGND VPWR VPWR sky130_fd_sc_hd__decap_3
XPHY_712 VGND VGND VPWR VPWR sky130_fd_sc_hd__decap_3
XPHY_723 VGND VGND VPWR VPWR sky130_fd_sc_hd__decap_3
XPHY_734 VGND VGND VPWR VPWR sky130_fd_sc_hd__decap_3
XPHY_756 VGND VGND VPWR VPWR sky130_fd_sc_hd__decap_3
XPHY_778 VGND VGND VPWR VPWR sky130_fd_sc_hd__decap_3
XPHY_767 VGND VGND VPWR VPWR sky130_fd_sc_hd__decap_3
XFILLER_0_108_513 VPWR VGND VPWR VGND sky130_ef_sc_hd__decap_12
XFILLER_0_110_1253 VGND VGND VPWR VPWR sky130_fd_sc_hd__decap_6
XFILLER_0_163_641 VGND VGND VPWR VPWR sky130_fd_sc_hd__decap_4
XFILLER_0_108_557 VPWR VGND VPWR VGND sky130_ef_sc_hd__decap_12
XFILLER_0_53_617 VPWR VGND VPWR VGND sky130_ef_sc_hd__decap_12
XFILLER_0_0_1315 VGND VGND VPWR VPWR sky130_fd_sc_hd__fill_1
XPHY_789 VGND VGND VPWR VPWR sky130_fd_sc_hd__decap_3
XFILLER_0_110_1297 VPWR VGND VPWR VGND sky130_ef_sc_hd__decap_12
XFILLER_0_20_29 VPWR VGND VPWR VGND sky130_ef_sc_hd__decap_12
XFILLER_0_104_741 VPWR VGND VPWR VGND sky130_ef_sc_hd__decap_12
XFILLER_0_1_909 VPWR VGND VPWR VGND sky130_ef_sc_hd__decap_12
XANTENNA_input62_A psum_col0_in[6] VGND VGND VPWR VPWR sky130_fd_sc_hd__diode_2
XFILLER_0_131_593 VPWR VGND VPWR VGND sky130_ef_sc_hd__decap_12
XFILLER_0_104_785 VPWR VGND VPWR VGND sky130_ef_sc_hd__decap_12
XFILLER_0_29_27 VPWR VGND VPWR VGND sky130_ef_sc_hd__decap_12
XFILLER_0_79_1255 VPWR VGND VPWR VGND sky130_ef_sc_hd__decap_12
XFILLER_0_219_1133 VPWR VGND VPWR VGND sky130_ef_sc_hd__decap_12
XFILLER_0_191_1303 VGND VGND VPWR VPWR sky130_fd_sc_hd__decap_6
XFILLER_0_45_37 VGND VGND VPWR VPWR sky130_fd_sc_hd__decap_8
XFILLER_0_219_1177 VPWR VGND VPWR VGND sky130_ef_sc_hd__decap_12
XFILLER_0_214_881 VPWR VGND VPWR VGND sky130_ef_sc_hd__decap_12
XFILLER_0_216_83 VGND VGND VPWR VPWR sky130_fd_sc_hd__fill_1
XFILLER_0_198_593 VPWR VGND VPWR VGND sky130_ef_sc_hd__decap_12
XFILLER_0_213_391 VGND VGND VPWR VPWR sky130_fd_sc_hd__fill_1
XTAP_2171 VGND VPWR sky130_fd_sc_hd__tapvpwrvgnd_1
XTAP_2160 VGND VPWR sky130_fd_sc_hd__tapvpwrvgnd_1
XFILLER_0_152_27 VGND VGND VPWR VPWR sky130_fd_sc_hd__fill_1
XFILLER_0_146_619 VPWR VGND VPWR VGND sky130_ef_sc_hd__decap_12
XTAP_2182 VGND VPWR sky130_fd_sc_hd__tapvpwrvgnd_1
XFILLER_0_61_47 VGND VGND VPWR VPWR sky130_fd_sc_hd__decap_3
XFILLER_0_29_647 VGND VGND VPWR VPWR sky130_fd_sc_hd__decap_8
XTAP_2193 VGND VPWR sky130_fd_sc_hd__tapvpwrvgnd_1
XFILLER_0_152_49 VGND VGND VPWR VPWR sky130_fd_sc_hd__fill_1
XTAP_1470 VGND VPWR sky130_fd_sc_hd__tapvpwrvgnd_1
XTAP_1481 VGND VPWR sky130_fd_sc_hd__tapvpwrvgnd_1
XFILLER_0_16_1283 VPWR VGND VPWR VGND sky130_ef_sc_hd__decap_12
XTAP_1492 VGND VPWR sky130_fd_sc_hd__tapvpwrvgnd_1
XFILLER_0_9_15 VPWR VGND VPWR VGND sky130_ef_sc_hd__decap_12
XFILLER_0_44_617 VGND VGND VPWR VPWR sky130_fd_sc_hd__fill_1
XFILLER_0_114_505 VPWR VGND VPWR VGND sky130_ef_sc_hd__decap_12
XFILLER_0_4_725 VPWR VGND VPWR VGND sky130_ef_sc_hd__decap_12
XFILLER_0_117_3 VPWR VGND VPWR VGND sky130_ef_sc_hd__decap_12
XFILLER_0_226_1159 VGND VGND VPWR VPWR sky130_fd_sc_hd__decap_3
XFILLER_0_4_769 VPWR VGND VPWR VGND sky130_ef_sc_hd__decap_12
XFILLER_0_122_593 VPWR VGND VPWR VGND sky130_ef_sc_hd__decap_12
XFILLER_0_3_279 VGND VGND VPWR VPWR sky130_fd_sc_hd__fill_1
XFILLER_0_110_755 VGND VGND VPWR VPWR sky130_fd_sc_hd__fill_1
XFILLER_0_62_1281 VGND VGND VPWR VPWR sky130_fd_sc_hd__fill_1
XFILLER_0_196_1225 VGND VGND VPWR VPWR sky130_fd_sc_hd__fill_1
XFILLER_0_97_1311 VPWR VGND VPWR VGND sky130_ef_sc_hd__decap_12
XFILLER_0_224_601 VPWR VGND VPWR VGND sky130_ef_sc_hd__decap_12
XFILLER_0_224_645 VPWR VGND VPWR VGND sky130_ef_sc_hd__decap_12
XFILLER_0_223_111 VGND VGND VPWR VPWR sky130_fd_sc_hd__fill_1
XFILLER_0_58_1339 VGND VGND VPWR VPWR sky130_fd_sc_hd__decap_4
XFILLER_0_211_317 VPWR VGND VPWR VGND sky130_ef_sc_hd__decap_12
XFILLER_0_189_593 VPWR VGND VPWR VGND sky130_ef_sc_hd__decap_12
XFILLER_0_133_1253 VGND VGND VPWR VPWR sky130_fd_sc_hd__fill_1
XFILLER_0_30_1225 VGND VGND VPWR VPWR sky130_fd_sc_hd__fill_1
XFILLER_0_145_641 VGND VGND VPWR VPWR sky130_fd_sc_hd__decap_4
XFILLER_0_35_617 VPWR VGND VPWR VGND sky130_ef_sc_hd__decap_12
XFILLER_0_105_505 VPWR VGND VPWR VGND sky130_ef_sc_hd__decap_12
XFILLER_0_7_585 VGND VGND VPWR VPWR sky130_fd_sc_hd__decap_3
XFILLER_0_160_655 VGND VGND VPWR VPWR sky130_fd_sc_hd__decap_4
XFILLER_0_219_417 VPWR VGND VPWR VGND sky130_ef_sc_hd__decap_12
XFILLER_0_140_1213 VPWR VGND VPWR VGND sky130_ef_sc_hd__decap_12
XFILLER_0_175_1309 VGND VGND VPWR VPWR sky130_fd_sc_hd__fill_1
XFILLER_0_216_1317 VPWR VGND VPWR VGND sky130_ef_sc_hd__decap_12
XFILLER_0_214_133 VGND VGND VPWR VPWR sky130_fd_sc_hd__decap_6
XFILLER_0_214_177 VPWR VGND VPWR VGND sky130_ef_sc_hd__decap_12
XFILLER_0_214_1085 VGND VGND VPWR VPWR sky130_fd_sc_hd__decap_6
XFILLER_0_211_895 VGND VGND VPWR VPWR sky130_fd_sc_hd__fill_1
XFILLER_0_210_361 VGND VGND VPWR VPWR sky130_fd_sc_hd__decap_3
XFILLER_0_112_1315 VGND VGND VPWR VPWR sky130_fd_sc_hd__fill_1
XFILLER_0_128_619 VPWR VGND VPWR VGND sky130_ef_sc_hd__decap_12
XPHY_542 VGND VGND VPWR VPWR sky130_fd_sc_hd__decap_3
XPHY_531 VGND VGND VPWR VPWR sky130_fd_sc_hd__decap_3
XFILLER_0_109_833 VGND VGND VPWR VPWR sky130_fd_sc_hd__decap_6
XPHY_553 VGND VGND VPWR VPWR sky130_fd_sc_hd__decap_3
XPHY_520 VGND VGND VPWR VPWR sky130_fd_sc_hd__decap_3
XPHY_1141 VGND VGND VPWR VPWR sky130_fd_sc_hd__decap_3
XPHY_1130 VGND VGND VPWR VPWR sky130_fd_sc_hd__decap_3
XPHY_564 VGND VGND VPWR VPWR sky130_fd_sc_hd__decap_3
XFILLER_0_26_617 VGND VGND VPWR VPWR sky130_fd_sc_hd__fill_1
XPHY_575 VGND VGND VPWR VPWR sky130_fd_sc_hd__decap_3
XPHY_586 VGND VGND VPWR VPWR sky130_fd_sc_hd__decap_3
XFILLER_0_108_321 VPWR VGND VPWR VGND sky130_ef_sc_hd__decap_12
XPHY_1152 VGND VGND VPWR VPWR sky130_fd_sc_hd__decap_3
XPHY_1174 VGND VGND VPWR VPWR sky130_fd_sc_hd__decap_3
XPHY_1163 VGND VGND VPWR VPWR sky130_fd_sc_hd__decap_3
XFILLER_0_202_41 VGND VGND VPWR VPWR sky130_fd_sc_hd__decap_8
XFILLER_0_110_1061 VPWR VGND VPWR VGND sky130_ef_sc_hd__decap_12
XPHY_597 VGND VGND VPWR VPWR sky130_fd_sc_hd__decap_3
XFILLER_0_109_877 VPWR VGND VPWR VGND sky130_ef_sc_hd__decap_12
XFILLER_0_108_365 VPWR VGND VPWR VGND sky130_ef_sc_hd__decap_12
XPHY_1185 VGND VGND VPWR VPWR sky130_fd_sc_hd__decap_3
XPHY_1196 VGND VGND VPWR VPWR sky130_fd_sc_hd__decap_3
XFILLER_0_151_655 VGND VGND VPWR VPWR sky130_fd_sc_hd__fill_2
XFILLER_0_221_1001 VGND VGND VPWR VPWR sky130_fd_sc_hd__decap_6
XFILLER_0_221_1045 VPWR VGND VPWR VGND sky130_ef_sc_hd__decap_12
XFILLER_0_221_1089 VPWR VGND VPWR VGND sky130_ef_sc_hd__decap_12
XFILLER_0_219_951 VGND VGND VPWR VPWR sky130_fd_sc_hd__fill_1
XFILLER_0_56_25 VGND VGND VPWR VPWR sky130_fd_sc_hd__decap_3
XFILLER_0_195_1291 VPWR VGND VPWR VGND sky130_ef_sc_hd__decap_12
XFILLER_0_221_615 VGND VGND VPWR VPWR sky130_fd_sc_hd__fill_1
XFILLER_0_156_1275 VGND VGND VPWR VPWR sky130_fd_sc_hd__decap_6
XFILLER_0_117_1237 VPWR VGND VPWR VGND sky130_ef_sc_hd__decap_12
XFILLER_0_163_15 VPWR VGND VPWR VGND sky130_ef_sc_hd__decap_12
XFILLER_0_92_1263 VPWR VGND VPWR VGND sky130_ef_sc_hd__decap_12
XFILLER_0_53_1225 VPWR VGND VPWR VGND sky130_ef_sc_hd__decap_12
XFILLER_0_5_1001 VGND VGND VPWR VPWR sky130_fd_sc_hd__decap_6
XFILLER_0_5_1045 VPWR VGND VPWR VGND sky130_ef_sc_hd__decap_12
XFILLER_0_127_641 VGND VGND VPWR VPWR sky130_fd_sc_hd__decap_4
XFILLER_0_17_617 VPWR VGND VPWR VGND sky130_ef_sc_hd__decap_12
XFILLER_0_5_1089 VPWR VGND VPWR VGND sky130_ef_sc_hd__decap_12
XFILLER_0_112_41 VPWR VGND VPWR VGND sky130_ef_sc_hd__decap_12
XFILLER_0_163_1213 VPWR VGND VPWR VGND sky130_ef_sc_hd__decap_12
XFILLER_0_4_533 VPWR VGND VPWR VGND sky130_ef_sc_hd__decap_12
XFILLER_0_112_85 VPWR VGND VPWR VGND sky130_ef_sc_hd__decap_12
XFILLER_0_142_655 VGND VGND VPWR VPWR sky130_fd_sc_hd__decap_4
XFILLER_0_40_631 VPWR VGND VPWR VGND sky130_ef_sc_hd__decap_12
XFILLER_0_163_1279 VPWR VGND VPWR VGND sky130_ef_sc_hd__decap_12
XFILLER_0_64_1343 VGND VGND VPWR VPWR sky130_fd_sc_hd__fill_1
XFILLER_0_0_783 VGND VGND VPWR VPWR sky130_fd_sc_hd__fill_1
XFILLER_0_225_921 VPWR VGND VPWR VGND sky130_ef_sc_hd__decap_12
XFILLER_0_41_3 VPWR VGND VPWR VGND sky130_ef_sc_hd__decap_12
XFILLER_0_225_965 VPWR VGND VPWR VGND sky130_ef_sc_hd__decap_12
XFILLER_0_174_1331 VGND VGND VPWR VPWR sky130_fd_sc_hd__decap_6
XFILLER_0_100_1263 VPWR VGND VPWR VGND sky130_ef_sc_hd__decap_12
XTAP_2918 VGND VPWR sky130_fd_sc_hd__tapvpwrvgnd_1
XTAP_2907 VGND VPWR sky130_fd_sc_hd__tapvpwrvgnd_1
XFILLER_0_212_637 VGND VGND VPWR VPWR sky130_fd_sc_hd__decap_6
XFILLER_0_224_475 VGND VGND VPWR VPWR sky130_fd_sc_hd__fill_1
XTAP_2929 VGND VPWR sky130_fd_sc_hd__tapvpwrvgnd_1
XFILLER_0_211_125 VPWR VGND VPWR VGND sky130_ef_sc_hd__decap_12
XFILLER_0_170_1239 VPWR VGND VPWR VGND sky130_ef_sc_hd__decap_12
XFILLER_0_71_1303 VGND VGND VPWR VPWR sky130_fd_sc_hd__decap_6
XFILLER_0_211_1225 VGND VGND VPWR VPWR sky130_fd_sc_hd__decap_6
XFILLER_0_211_169 VPWR VGND VPWR VGND sky130_ef_sc_hd__decap_12
XFILLER_0_220_681 VPWR VGND VPWR VGND sky130_ef_sc_hd__decap_12
XFILLER_0_1_93 VPWR VGND VPWR VGND sky130_ef_sc_hd__decap_12
XFILLER_0_211_1269 VPWR VGND VPWR VGND sky130_ef_sc_hd__decap_12
XFILLER_0_106_825 VPWR VGND VPWR VGND sky130_ef_sc_hd__decap_12
XFILLER_0_7_393 VPWR VGND VPWR VGND sky130_ef_sc_hd__decap_12
XFILLER_0_105_335 VGND VGND VPWR VPWR sky130_fd_sc_hd__fill_1
XFILLER_0_181_1335 VGND VGND VPWR VPWR sky130_fd_sc_hd__decap_8
XFILLER_0_133_655 VGND VGND VPWR VPWR sky130_fd_sc_hd__fill_2
XFILLER_0_106_869 VPWR VGND VPWR VGND sky130_ef_sc_hd__decap_12
XFILLER_0_142_1319 VPWR VGND VPWR VGND sky130_ef_sc_hd__decap_12
XANTENNA_input164_A w11[9] VGND VGND VPWR VPWR sky130_fd_sc_hd__diode_2
XFILLER_0_219_225 VPWR VGND VPWR VGND sky130_ef_sc_hd__decap_12
XFILLER_0_179_1253 VGND VGND VPWR VPWR sky130_fd_sc_hd__fill_1
XANTENNA_input25_A act_row1_in[2] VGND VGND VPWR VPWR sky130_fd_sc_hd__diode_2
XFILLER_0_76_1225 VGND VGND VPWR VPWR sky130_fd_sc_hd__fill_1
XFILLER_0_215_497 VGND VGND VPWR VPWR sky130_fd_sc_hd__decap_6
XFILLER_0_98_631 VPWR VGND VPWR VGND sky130_ef_sc_hd__decap_12
XFILLER_0_216_1147 VGND VGND VPWR VPWR sky130_fd_sc_hd__fill_1
XFILLER_0_116_1281 VGND VGND VPWR VPWR sky130_fd_sc_hd__fill_1
XFILLER_0_42_49 VGND VGND VPWR VPWR sky130_fd_sc_hd__fill_1
XFILLER_0_186_1213 VPWR VGND VPWR VGND sky130_ef_sc_hd__decap_12
XFILLER_0_220_9 VGND VGND VPWR VPWR sky130_fd_sc_hd__fill_2
XFILLER_0_109_641 VPWR VGND VPWR VGND sky130_ef_sc_hd__decap_12
XPHY_361 VGND VGND VPWR VPWR sky130_fd_sc_hd__decap_3
XFILLER_0_2_1229 VPWR VGND VPWR VGND sky130_ef_sc_hd__decap_12
XPHY_350 VGND VGND VPWR VPWR sky130_fd_sc_hd__decap_3
XPHY_383 VGND VGND VPWR VPWR sky130_fd_sc_hd__decap_3
XPHY_394 VGND VGND VPWR VPWR sky130_fd_sc_hd__decap_3
XPHY_372 VGND VGND VPWR VPWR sky130_fd_sc_hd__decap_3
XFILLER_0_13_1253 VGND VGND VPWR VPWR sky130_fd_sc_hd__fill_1
XFILLER_0_87_1343 VGND VGND VPWR VPWR sky130_fd_sc_hd__fill_1
XFILLER_0_109_685 VPWR VGND VPWR VGND sky130_ef_sc_hd__decap_12
XFILLER_0_124_655 VGND VGND VPWR VPWR sky130_fd_sc_hd__decap_4
XFILLER_0_101_6 VGND VGND VPWR VPWR sky130_fd_sc_hd__fill_2
XFILLER_0_108_195 VGND VGND VPWR VPWR sky130_fd_sc_hd__fill_1
XFILLER_0_1_503 VGND VGND VPWR VPWR sky130_fd_sc_hd__fill_1
XFILLER_0_22_631 VPWR VGND VPWR VGND sky130_ef_sc_hd__decap_12
XFILLER_0_111_305 VPWR VGND VPWR VGND sky130_ef_sc_hd__decap_12
XFILLER_0_6_27 VGND VGND VPWR VPWR sky130_fd_sc_hd__fill_1
XFILLER_0_111_349 VPWR VGND VPWR VGND sky130_ef_sc_hd__decap_12
XFILLER_0_158_15 VPWR VGND VPWR VGND sky130_ef_sc_hd__decap_12
XFILLER_0_197_1331 VGND VGND VPWR VPWR sky130_fd_sc_hd__fill_2
XFILLER_0_20_1213 VPWR VGND VPWR VGND sky130_ef_sc_hd__decap_12
XFILLER_0_225_217 VGND VGND VPWR VPWR sky130_fd_sc_hd__decap_6
XFILLER_0_184_3 VPWR VGND VPWR VGND sky130_ef_sc_hd__decap_12
XFILLER_0_158_1337 VGND VGND VPWR VPWR sky130_fd_sc_hd__fill_1
XFILLER_0_55_1309 VGND VGND VPWR VPWR sky130_fd_sc_hd__fill_1
XFILLER_0_222_979 VGND VGND VPWR VPWR sky130_fd_sc_hd__fill_1
XFILLER_0_130_1201 VPWR VGND VPWR VGND sky130_ef_sc_hd__decap_12
XFILLER_0_9_647 VPWR VGND VPWR VGND sky130_ef_sc_hd__decap_12
XFILLER_0_5_853 VPWR VGND VPWR VGND sky130_ef_sc_hd__decap_12
XFILLER_0_89_3 VPWR VGND VPWR VGND sky130_ef_sc_hd__decap_12
XFILLER_0_4_363 VGND VGND VPWR VPWR sky130_fd_sc_hd__fill_1
XFILLER_0_5_897 VPWR VGND VPWR VGND sky130_ef_sc_hd__decap_12
XFILLER_0_114_165 VGND VGND VPWR VPWR sky130_fd_sc_hd__decap_3
XFILLER_0_217_729 VPWR VGND VPWR VGND sky130_ef_sc_hd__decap_12
XFILLER_0_218_29 VPWR VGND VPWR VGND sky130_ef_sc_hd__decap_12
XFILLER_0_99_1225 VPWR VGND VPWR VGND sky130_ef_sc_hd__decap_12
XFILLER_0_212_401 VPWR VGND VPWR VGND sky130_ef_sc_hd__decap_12
XTAP_2704 VGND VPWR sky130_fd_sc_hd__tapvpwrvgnd_1
XTAP_2726 VGND VPWR sky130_fd_sc_hd__tapvpwrvgnd_1
XFILLER_0_197_647 VPWR VGND VPWR VGND sky130_ef_sc_hd__decap_12
XTAP_2715 VGND VPWR sky130_fd_sc_hd__tapvpwrvgnd_1
XTAP_2737 VGND VPWR sky130_fd_sc_hd__tapvpwrvgnd_1
XFILLER_0_212_445 VPWR VGND VPWR VGND sky130_ef_sc_hd__decap_12
XTAP_2748 VGND VPWR sky130_fd_sc_hd__tapvpwrvgnd_1
XTAP_2759 VGND VPWR sky130_fd_sc_hd__tapvpwrvgnd_1
XFILLER_0_212_489 VPWR VGND VPWR VGND sky130_ef_sc_hd__decap_12
XFILLER_0_75_1291 VPWR VGND VPWR VGND sky130_ef_sc_hd__decap_12
XFILLER_0_211_1033 VPWR VGND VPWR VGND sky130_ef_sc_hd__decap_12
XFILLER_0_95_645 VGND VGND VPWR VPWR sky130_fd_sc_hd__fill_1
XFILLER_0_36_1275 VGND VGND VPWR VPWR sky130_fd_sc_hd__decap_6
XFILLER_0_211_1077 VPWR VGND VPWR VGND sky130_ef_sc_hd__decap_12
XFILLER_0_146_1263 VPWR VGND VPWR VGND sky130_ef_sc_hd__decap_12
XFILLER_0_107_1225 VGND VGND VPWR VPWR sky130_fd_sc_hd__decap_6
XFILLER_0_106_699 VGND VGND VPWR VPWR sky130_fd_sc_hd__fill_1
XFILLER_0_121_647 VPWR VGND VPWR VGND sky130_ef_sc_hd__decap_12
XFILLER_0_43_1213 VPWR VGND VPWR VGND sky130_ef_sc_hd__decap_12
XFILLER_0_82_1251 VPWR VGND VPWR VGND sky130_ef_sc_hd__decap_12
XFILLER_0_107_1269 VPWR VGND VPWR VGND sky130_ef_sc_hd__decap_12
XFILLER_0_82_1295 VPWR VGND VPWR VGND sky130_ef_sc_hd__decap_12
XFILLER_0_222_1173 VPWR VGND VPWR VGND sky130_ef_sc_hd__decap_12
XFILLER_0_43_1279 VPWR VGND VPWR VGND sky130_ef_sc_hd__decap_12
XFILLER_0_37_27 VPWR VGND VPWR VGND sky130_ef_sc_hd__decap_12
XFILLER_0_128_29 VPWR VGND VPWR VGND sky130_ef_sc_hd__decap_12
Xinput152 w11[12] VGND VGND VPWR VPWR net152 sky130_fd_sc_hd__clkbuf_8
Xinput163 w11[8] VGND VGND VPWR VPWR net163 sky130_fd_sc_hd__clkbuf_8
Xinput141 w10[2] VGND VGND VPWR VPWR net141 sky130_fd_sc_hd__clkbuf_4
Xinput130 w01[7] VGND VGND VPWR VPWR net130 sky130_fd_sc_hd__buf_4
XFILLER_0_222_209 VPWR VGND VPWR VGND sky130_ef_sc_hd__decap_12
XFILLER_0_215_261 VPWR VGND VPWR VGND sky130_ef_sc_hd__decap_12
XFILLER_0_153_1201 VPWR VGND VPWR VGND sky130_ef_sc_hd__decap_12
XANTENNA_output229_A net229 VGND VGND VPWR VPWR sky130_fd_sc_hd__diode_2
XFILLER_0_192_1283 VPWR VGND VPWR VGND sky130_ef_sc_hd__decap_12
XFILLER_0_118_1343 VGND VGND VPWR VPWR sky130_fd_sc_hd__fill_1
XFILLER_0_53_15 VPWR VGND VPWR VGND sky130_ef_sc_hd__decap_12
XFILLER_0_153_1267 VPWR VGND VPWR VGND sky130_ef_sc_hd__decap_12
XFILLER_0_54_1331 VGND VGND VPWR VPWR sky130_fd_sc_hd__decap_6
XFILLER_0_114_1229 VGND VGND VPWR VPWR sky130_fd_sc_hd__decap_3
XFILLER_0_188_1319 VPWR VGND VPWR VGND sky130_ef_sc_hd__decap_12
XFILLER_0_224_83 VGND VGND VPWR VPWR sky130_fd_sc_hd__fill_1
XFILLER_0_6_1173 VPWR VGND VPWR VGND sky130_ef_sc_hd__decap_12
XFILLER_0_50_1239 VPWR VGND VPWR VGND sky130_ef_sc_hd__decap_12
XFILLER_0_160_27 VGND VGND VPWR VPWR sky130_fd_sc_hd__fill_1
XFILLER_0_2_1037 VPWR VGND VPWR VGND sky130_ef_sc_hd__decap_12
XFILLER_0_160_49 VGND VGND VPWR VPWR sky130_fd_sc_hd__fill_1
XPHY_191 VGND VGND VPWR VPWR sky130_fd_sc_hd__decap_3
XFILLER_0_5_105 VGND VGND VPWR VPWR sky130_fd_sc_hd__decap_6
XPHY_180 VGND VGND VPWR VPWR sky130_fd_sc_hd__decap_3
XFILLER_0_5_149 VPWR VGND VPWR VGND sky130_ef_sc_hd__decap_12
XFILLER_0_125_1303 VGND VGND VPWR VPWR sky130_fd_sc_hd__decap_6
XFILLER_0_112_625 VPWR VGND VPWR VGND sky130_ef_sc_hd__decap_12
XFILLER_0_160_1227 VPWR VGND VPWR VGND sky130_ef_sc_hd__decap_12
XFILLER_0_2_867 VGND VGND VPWR VPWR sky130_fd_sc_hd__fill_1
XFILLER_0_111_113 VPWR VGND VPWR VGND sky130_ef_sc_hd__decap_12
XFILLER_0_169_47 VGND VGND VPWR VPWR sky130_fd_sc_hd__fill_1
XFILLER_0_112_669 VPWR VGND VPWR VGND sky130_ef_sc_hd__decap_12
XFILLER_0_61_1335 VGND VGND VPWR VPWR sky130_fd_sc_hd__decap_8
XFILLER_0_201_1213 VPWR VGND VPWR VGND sky130_ef_sc_hd__decap_12
XFILLER_0_185_13 VPWR VGND VPWR VGND sky130_ef_sc_hd__decap_12
XFILLER_0_22_1319 VPWR VGND VPWR VGND sky130_ef_sc_hd__decap_12
XFILLER_0_201_1279 VPWR VGND VPWR VGND sky130_ef_sc_hd__decap_12
XFILLER_0_226_548 VGND VGND VPWR VPWR sky130_fd_sc_hd__decap_3
XFILLER_0_94_22 VGND VGND VPWR VPWR sky130_fd_sc_hd__decap_6
.ends
